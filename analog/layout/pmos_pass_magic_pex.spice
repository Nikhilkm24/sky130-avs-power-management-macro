* SPICE3 file created from pmos_pass_2000u.ext - technology: sky130A

.option scale=10000u

X0 a_385_0# a_370_n20# a_330_0# w_n400_n400# sky130_fd_pr__pfet_01v8 ad=5.46433e+08 pd=25030 as=5.59838e+08 ps=25030 w=3125 l=15
X1 a_605_0# a_590_n20# a_550_0# w_n400_n400# sky130_fd_pr__pfet_01v8 ad=5.59835e+08 pd=25030 as=5.59836e+08 ps=25030 w=3125 l=15
X2 a_2420_0# a_2405_n20# a_2365_0# w_n400_n400# sky130_fd_pr__pfet_01v8 ad=524288 pd=0 as=-65 ps=-1 w=3125 l=15
X3 a_1430_0# a_1415_n20# a_1375_0# w_n400_n400# sky130_fd_pr__pfet_01v8 ad=5.62936e+08 pd=25030 as=392 ps=285 w=3125 l=15
X4 a_2640_0# a_2625_n20# a_2585_0# w_n400_n400# sky130_fd_pr__pfet_01v8 ad=524288 pd=0 as=5 ps=8 w=3125 l=15
X5 a_1650_0# a_1635_n20# a_1595_0# w_n400_n400# sky130_fd_pr__pfet_01v8 ad=4.46464e+06 pd=0 as=1.23125e+07 ps=0 w=3125 l=15
X6 a_1815_0# a_1800_n20# a_1760_0# w_n400_n400# sky130_fd_pr__pfet_01v8 ad=524288 pd=0 as=524288 ps=0 w=3125 l=15
X7 a_2860_0# a_2845_n20# a_2805_0# w_n400_n400# sky130_fd_pr__pfet_01v8 ad=-1.81613e+09 pd=-174241 as=-6.71089e+07 ps=1.07373e+08 w=3125 l=15
X8 a_1870_0# a_1855_n20# a_1815_0# w_n400_n400# sky130_fd_pr__pfet_01v8 ad=524288 pd=0 as=0 ps=0 w=3125 l=15
X9 a_3135_0# a_3120_n20# a_3080_0# w_n400_n400# sky130_fd_pr__pfet_01v8 ad=150 pd=0 as=6.71087e+07 ps=0 w=3125 l=15
X10 a_2145_0# a_2130_n20# a_2090_0# w_n400_n400# sky130_fd_pr__pfet_01v8 ad=524288 pd=0 as=524288 ps=0 w=3125 l=15
X11 a_3190_0# a_3175_n20# a_3135_0# w_n400_n400# sky130_fd_pr__pfet_01v8 ad=5 pd=8 as=0 ps=0 w=3125 l=15
X12 a_3355_0# a_3340_n20# a_3300_0# w_n400_n400# sky130_fd_pr__pfet_01v8 ad=1.67772e+07 pd=0 as=524288 ps=0 w=3125 l=15
X13 a_1155_0# a_1140_n20# a_1100_0# w_n400_n400# sky130_fd_pr__pfet_01v8 ad=5.55097e+08 pd=25030 as=5.66485e+08 ps=25030 w=3125 l=15
X14 a_2200_0# a_2185_n20# a_2145_0# w_n400_n400# sky130_fd_pr__pfet_01v8 ad=17 pd=0 as=0 ps=0 w=3125 l=15
X15 a_2365_0# a_2350_n20# a_2310_0# w_n400_n400# sky130_fd_pr__pfet_01v8 ad=-0 pd=-0 as=524288 ps=0 w=3125 l=15
X16 a_3410_0# a_3395_n20# a_3355_0# w_n400_n400# sky130_fd_pr__pfet_01v8 ad=-6.71089e+07 pd=-2.68434e+07 as=0 ps=0 w=3125 l=15
X17 a_330_0# a_315_n20# a_275_0# w_n400_n400# sky130_fd_pr__pfet_01v8 ad=0 pd=0 as=5.46441e+08 ps=25030 w=3125 l=15
X18 a_1210_0# a_1195_n20# a_1155_0# w_n400_n400# sky130_fd_pr__pfet_01v8 ad=524288 pd=0 as=0 ps=0 w=3125 l=15
X19 a_1375_0# a_1360_n20# a_1320_0# w_n400_n400# sky130_fd_pr__pfet_01v8 ad=0 pd=0 as=0 ps=0 w=3125 l=15
X20 a_2585_0# a_2570_n20# a_2530_0# w_n400_n400# sky130_fd_pr__pfet_01v8 ad=0 pd=0 as=1.02356e+09 ps=25024 w=3125 l=15
X21 a_550_0# a_535_n20# a_495_0# w_n400_n400# sky130_fd_pr__pfet_01v8 ad=0 pd=0 as=5.43637e+08 ps=25030 w=3125 l=15
X22 a_715_0# a_700_n20# a_660_0# w_n400_n400# sky130_fd_pr__pfet_01v8 ad=1.02365e+09 pd=25024 as=17 ps=0 w=3125 l=15
X23 a_1595_0# a_1580_n20# a_1540_0# w_n400_n400# sky130_fd_pr__pfet_01v8 ad=0 pd=0 as=125 ps=0 w=3125 l=15
X24 a_2805_0# a_2790_n20# a_2750_0# w_n400_n400# sky130_fd_pr__pfet_01v8 ad=-0 pd=0 as=5.5159e+06 ps=0 w=3125 l=15
X25 a_770_0# a_755_n20# a_715_0# w_n400_n400# sky130_fd_pr__pfet_01v8 ad=1.02356e+09 pd=25024 as=0 ps=0 w=3125 l=15
X26 a_935_0# a_920_n20# a_880_0# w_n400_n400# sky130_fd_pr__pfet_01v8 ad=-262143 pd=-1.67772e+07 as=5 ps=8 w=3125 l=15
X27 a_990_0# a_975_n20# a_935_0# w_n400_n400# sky130_fd_pr__pfet_01v8 ad=60 pd=0 as=-0 ps=-0 w=3125 l=15
X28 a_55_0# a_40_n20# a_0_0# w_n400_n400# sky130_fd_pr__pfet_01v8 ad=5.55158e+08 pd=25030 as=1 ps=0 w=3125 l=15
X29 a_275_0# a_260_n20# a_220_0# w_n400_n400# sky130_fd_pr__pfet_01v8 ad=0 pd=0 as=5.64157e+08 ps=25030 w=3125 l=15
X30 a_110_0# a_95_n20# a_55_0# w_n400_n400# sky130_fd_pr__pfet_01v8 ad=1.23125e+07 pd=0 as=0 ps=0 w=3125 l=15
X31 a_495_0# a_480_n20# a_440_0# w_n400_n400# sky130_fd_pr__pfet_01v8 ad=0 pd=0 as=5.43658e+08 ps=25030 w=3125 l=15
X32 a_3520_0# a_3505_n20# a_3465_0# w_n400_n400# sky130_fd_pr__pfet_01v8 ad=524288 pd=0 as=0 ps=8 w=3125 l=15
X33 a_1320_0# a_1305_n20# a_1265_0# w_n400_n400# sky130_fd_pr__pfet_01v8 ad=0 pd=0 as=5 ps=8 w=3125 l=15
X34 a_2530_0# a_2515_n20# a_2475_0# w_n400_n400# sky130_fd_pr__pfet_01v8 ad=0 pd=0 as=5 ps=8 w=3125 l=15
X35 a_1540_0# a_1525_n20# a_1485_0# w_n400_n400# sky130_fd_pr__pfet_01v8 ad=0 pd=0 as=8.75651e+08 ps=1.85173e+09 w=3125 l=15
X36 a_2750_0# a_2735_n20# a_2695_0# w_n400_n400# sky130_fd_pr__pfet_01v8 ad=0 pd=0 as=5.59871e+08 ps=25030 w=3125 l=15
X37 a_2915_0# a_2900_n20# a_2860_0# w_n400_n400# sky130_fd_pr__pfet_01v8 ad=0 pd=8 as=-0 ps=-0 w=3125 l=15
X38 a_1760_0# a_1745_n20# a_1705_0# w_n400_n400# sky130_fd_pr__pfet_01v8 ad=0 pd=0 as=-1.81613e+09 ps=-174241 w=3125 l=15
X39 a_1925_0# a_1910_n20# a_1870_0# w_n400_n400# sky130_fd_pr__pfet_01v8 ad=524288 pd=0 as=0 ps=0 w=3125 l=15
X40 a_2970_0# a_2955_n20# a_2915_0# w_n400_n400# sky130_fd_pr__pfet_01v8 ad=1.65436e+07 pd=0 as=0 ps=0 w=3125 l=15
X41 a_1980_0# a_1965_n20# a_1925_0# w_n400_n400# sky130_fd_pr__pfet_01v8 ad=524288 pd=0 as=0 ps=0 w=3125 l=15
X42 a_3025_0# a_3010_n20# a_2970_0# w_n400_n400# sky130_fd_pr__pfet_01v8 ad=-6.71089e+07 pd=-2.68434e+07 as=0 ps=0 w=3125 l=15
X43 a_2035_0# a_2020_n20# a_1980_0# w_n400_n400# sky130_fd_pr__pfet_01v8 ad=524288 pd=0 as=0 ps=0 w=3125 l=15
X44 a_3245_0# a_3230_n20# a_3190_0# w_n400_n400# sky130_fd_pr__pfet_01v8 ad=1.02355e+09 pd=25024 as=0 ps=0 w=3125 l=15
X45 a_1045_0# a_1030_n20# a_990_0# w_n400_n400# sky130_fd_pr__pfet_01v8 ad=233536 pd=0 as=0 ps=0 w=3125 l=15
X46 a_2255_0# a_2240_n20# a_2200_0# w_n400_n400# sky130_fd_pr__pfet_01v8 ad=524288 pd=0 as=0 ps=0 w=3125 l=15
X47 a_3080_0# a_3065_n20# a_3025_0# w_n400_n400# sky130_fd_pr__pfet_01v8 ad=0 pd=0 as=-0 ps=-0 w=3125 l=15
X48 a_2090_0# a_2075_n20# a_2035_0# w_n400_n400# sky130_fd_pr__pfet_01v8 ad=0 pd=0 as=0 ps=0 w=3125 l=15
X49 a_3300_0# a_3285_n20# a_3245_0# w_n400_n400# sky130_fd_pr__pfet_01v8 ad=0 pd=0 as=0 ps=0 w=3125 l=15
X50 a_3465_0# a_3450_n20# a_3410_0# w_n400_n400# sky130_fd_pr__pfet_01v8 ad=0 pd=0 as=-0 ps=-0 w=3125 l=15
X51 a_220_0# a_205_n20# a_165_0# w_n400_n400# sky130_fd_pr__pfet_01v8 ad=0 pd=0 as=4.46464e+06 ps=0 w=3125 l=15
X52 a_1100_0# a_1085_n20# a_1045_0# w_n400_n400# sky130_fd_pr__pfet_01v8 ad=0 pd=0 as=0 ps=0 w=3125 l=15
X53 a_1265_0# a_1250_n20# a_1210_0# w_n400_n400# sky130_fd_pr__pfet_01v8 ad=0 pd=0 as=0 ps=0 w=3125 l=15
X54 a_2310_0# a_2295_n20# a_2255_0# w_n400_n400# sky130_fd_pr__pfet_01v8 ad=0 pd=0 as=0 ps=0 w=3125 l=15
X55 a_2475_0# a_2460_n20# a_2420_0# w_n400_n400# sky130_fd_pr__pfet_01v8 ad=0 pd=0 as=0 ps=0 w=3125 l=15
X56 a_440_0# a_425_n20# a_385_0# w_n400_n400# sky130_fd_pr__pfet_01v8 ad=0 pd=0 as=0 ps=0 w=3125 l=15
X57 a_1485_0# a_1470_n20# a_1430_0# w_n400_n400# sky130_fd_pr__pfet_01v8 ad=0 pd=0 as=0 ps=0 w=3125 l=15
X58 a_2695_0# a_2680_n20# a_2640_0# w_n400_n400# sky130_fd_pr__pfet_01v8 ad=0 pd=0 as=0 ps=0 w=3125 l=15
X59 a_660_0# a_645_n20# a_605_0# w_n400_n400# sky130_fd_pr__pfet_01v8 ad=0 pd=0 as=0 ps=0 w=3125 l=15
X60 a_825_0# a_810_n20# a_770_0# w_n400_n400# sky130_fd_pr__pfet_01v8 ad=-65 pd=-1 as=0 ps=0 w=3125 l=15
X61 a_1705_0# a_1690_n20# a_1650_0# w_n400_n400# sky130_fd_pr__pfet_01v8 ad=-0 pd=-0 as=0 ps=0 w=3125 l=15
X62 a_880_0# a_865_n20# a_825_0# w_n400_n400# sky130_fd_pr__pfet_01v8 ad=0 pd=0 as=-0 ps=-0 w=3125 l=15
X63 a_165_0# a_150_n20# a_110_0# w_n400_n400# sky130_fd_pr__pfet_01v8 ad=0 pd=0 as=0 ps=0 w=3125 l=15
C0 a_810_n20# a_1360_n20# 0.00fF
C1 VDD_1V8 a_1855_n20# 1.46fF
C2 a_1580_n20# a_1250_n20# 0.00fF
C3 a_810_n20# a_1140_n20# 0.00fF
C4 a_920_n20# a_1195_n20# 0.00fF
C5 a_1690_n20# a_2185_n20# 0.00fF
C6 w_n400_n400# a_2680_n20# 0.07fF
C7 w_n400_n400# a_2130_n20# 0.07fF
C8 a_2515_n20# a_2625_n20# 0.01fF
C9 a_1360_n20# a_1140_n20# 0.00fF
C10 a_645_n20# a_535_n20# 0.01fF
C11 VDD_1V8 a_880_0# 0.42fF
C12 a_2570_n20# a_3120_n20# 0.00fF
C13 a_1635_n20# a_1910_n20# 0.00fF
C14 VDD_CORE a_1635_n20# 1.46fF
C15 VDD_CORE a_590_n20# 1.46fF
C16 VDD_1V8 a_1540_0# 0.42fF
C17 a_1085_n20# a_1690_n20# 0.00fF
C18 a_1635_n20# a_1800_n20# 0.00fF
C19 VDD_1V8 a_810_n20# 1.46fF
C20 a_1965_n20# a_1580_n20# 0.00fF
C21 a_2130_n20# a_2735_n20# 0.00fF
C22 a_865_n20# a_1030_n20# 0.00fF
C23 VDD_1V8 a_1360_n20# 1.46fF
C24 a_2680_n20# a_2735_n20# 0.02fF
C25 a_865_n20# a_755_n20# 0.01fF
C26 a_3010_n20# a_2460_n20# 0.00fF
C27 VDD_1V8 a_1140_n20# 1.46fF
C28 a_1690_n20# a_1580_n20# 0.01fF
C29 a_2680_n20# a_2900_n20# 0.00fF
C30 a_150_n20# a_480_n20# 0.00fF
C31 w_n400_n400# a_1525_n20# 0.07fF
C32 a_3010_n20# a_2790_n20# 0.00fF
C33 a_2845_n20# a_2405_n20# 0.00fF
C34 a_700_n20# a_590_n20# 0.01fF
C35 a_2295_n20# a_2185_n20# 0.01fF
C36 a_2680_n20# a_2350_n20# 0.00fF
C37 a_2405_n20# a_2075_n20# 0.00fF
C38 a_2350_n20# a_2130_n20# 0.00fF
C39 w_n400_n400# a_3505_n20# 0.07fF
C40 VDD_1V8 a_1650_0# 0.42fF
C41 VDD_CORE a_535_n20# 1.46fF
C42 a_920_n20# a_810_n20# 0.01fF
C43 a_2955_n20# a_2845_n20# 0.01fF
C44 VDD_CORE a_165_0# 0.42fF
C45 VDD_1V8 a_2240_n20# 1.46fF
C46 a_3285_n20# a_2790_n20# 0.00fF
C47 a_920_n20# a_1360_n20# 0.00fF
C48 a_150_n20# a_205_n20# 0.02fF
C49 a_1635_n20# a_1470_n20# 0.00fF
C50 a_920_n20# a_1140_n20# 0.00fF
C51 a_1030_n20# a_1195_n20# 0.00fF
C52 a_1195_n20# a_755_n20# 0.00fF
C53 a_2680_n20# a_2625_n20# 0.02fF
C54 a_2130_n20# a_2625_n20# 0.00fF
C55 a_700_n20# a_535_n20# 0.00fF
C56 w_n400_n400# a_1745_n20# 0.07fF
C57 a_1635_n20# a_2185_n20# 0.00fF
C58 a_2900_n20# a_3505_n20# 0.00fF
C59 a_260_n20# a_370_n20# 0.01fF
C60 VDD_CORE a_1815_0# 0.42fF
C61 VDD_1V8 a_920_n20# 1.46fF
C62 a_2020_n20# a_2405_n20# 0.00fF
C63 a_1085_n20# a_1635_n20# 0.00fF
C64 a_865_n20# w_n400_n400# 0.07fF
C65 a_1085_n20# a_590_n20# 0.00fF
C66 VDD_1V8 a_220_0# 0.42fF
C67 a_3010_n20# a_3395_n20# 0.00fF
C68 a_2680_n20# a_3230_n20# 0.00fF
C69 VDD_CORE a_3010_n20# 1.46fF
C70 a_975_n20# a_1525_n20# 0.00fF
C71 VDD_CORE a_715_0# 0.42fF
C72 w_n400_n400# a_2570_n20# 0.07fF
C73 VDD_1V8 a_3065_n20# 1.46fF
C74 a_1635_n20# a_1580_n20# 0.02fF
C75 a_3285_n20# a_3395_n20# 0.01fF
C76 VDD_CORE a_3285_n20# 1.46fF
C77 a_1745_n20# a_2350_n20# 0.00fF
C78 a_1030_n20# a_810_n20# 0.00fF
C79 a_810_n20# a_755_n20# 0.02fF
C80 a_2405_n20# a_2460_n20# 0.02fF
C81 a_1030_n20# a_1360_n20# 0.00fF
C82 a_480_n20# a_590_n20# 0.01fF
C83 a_2845_n20# a_2515_n20# 0.00fF
C84 a_3010_n20# a_3175_n20# 0.00fF
C85 a_2790_n20# a_2405_n20# 0.00fF
C86 a_2075_n20# a_2515_n20# 0.00fF
C87 a_1360_n20# a_755_n20# 0.00fF
C88 VDD_1V8 a_3120_n20# 1.46fF
C89 a_1085_n20# a_535_n20# 0.00fF
C90 a_2570_n20# a_2735_n20# 0.00fF
C91 a_3450_n20# a_3340_n20# 0.01fF
C92 a_2955_n20# a_2460_n20# 0.00fF
C93 a_1690_n20# a_1250_n20# 0.00fF
C94 w_n400_n400# a_1195_n20# 0.07fF
C95 a_1030_n20# a_1140_n20# 0.01fF
C96 a_1140_n20# a_755_n20# 0.00fF
C97 a_2955_n20# a_2790_n20# 0.00fF
C98 a_2570_n20# a_2900_n20# 0.00fF
C99 a_3285_n20# a_3175_n20# 0.01fF
C100 VDD_1V8 a_95_n20# 1.46fF
C101 a_2570_n20# a_2350_n20# 0.00fF
C102 a_3230_n20# a_3505_n20# 0.00fF
C103 a_205_n20# a_590_n20# 0.00fF
C104 VDD_1V8 a_2640_0# 0.42fF
C105 a_1690_n20# a_1965_n20# 0.00fF
C106 VDD_1V8 a_1030_n20# 1.46fF
C107 w_n400_n400# a_1855_n20# 0.07fF
C108 VDD_1V8 a_755_n20# 1.46fF
C109 a_480_n20# a_535_n20# 0.02fF
C110 a_975_n20# a_865_n20# 0.01fF
C111 VDD_1V8 a_1760_0# 0.42fF
C112 VDD_CORE a_2585_0# 0.42fF
C113 a_2570_n20# a_2625_n20# 0.02fF
C114 a_3065_n20# a_3120_n20# 0.02fF
C115 a_2020_n20# a_2515_n20# 0.00fF
C116 a_260_n20# a_425_n20# 0.00fF
C117 a_205_n20# a_535_n20# 0.00fF
C118 a_260_n20# a_315_n20# 0.02fF
C119 a_810_n20# w_n400_n400# 0.07fF
C120 a_1030_n20# a_920_n20# 0.01fF
C121 a_1910_n20# a_2405_n20# 0.00fF
C122 a_920_n20# a_755_n20# 0.00fF
C123 VDD_CORE a_2405_n20# 1.46fF
C124 w_n400_n400# a_1360_n20# 0.07fF
C125 a_2680_n20# a_2845_n20# 0.00fF
C126 a_2680_n20# a_2075_n20# 0.00fF
C127 a_2405_n20# a_1800_n20# 0.00fF
C128 a_2130_n20# a_2075_n20# 0.02fF
C129 a_2295_n20# a_1965_n20# 0.00fF
C130 a_2350_n20# a_1855_n20# 0.00fF
C131 a_2955_n20# a_3395_n20# 0.00fF
C132 VDD_CORE a_2955_n20# 1.46fF
C133 a_975_n20# a_1195_n20# 0.00fF
C134 w_n400_n400# a_1140_n20# 0.07fF
C135 VDD_CORE a_2255_0# 0.42fF
C136 a_2515_n20# a_2460_n20# 0.02fF
C137 a_1635_n20# a_1250_n20# 0.00fF
C138 a_2790_n20# a_2515_n20# 0.00fF
C139 a_1690_n20# a_2295_n20# 0.00fF
C140 w_n400_n400# a_2240_n20# 0.07fF
C141 a_865_n20# a_370_n20# 0.00fF
C142 VDD_1V8 a_3190_0# 0.42fF
C143 a_3025_0# VDD_CORE 0.42fF
C144 a_2955_n20# a_3175_n20# 0.00fF
C145 VDD_1V8 w_n400_n400# 106.09fF
C146 VDD_1V8 a_40_n20# 1.46fF
C147 a_1635_n20# a_1965_n20# 0.00fF
C148 a_2075_n20# a_1525_n20# 0.00fF
C149 a_1415_n20# a_1525_n20# 0.01fF
C150 VDD_CORE a_2915_0# 0.42fF
C151 a_2240_n20# a_2735_n20# 0.00fF
C152 a_150_n20# a_590_n20# 0.00fF
C153 a_2020_n20# a_2130_n20# 0.01fF
C154 VDD_1V8 a_2735_n20# 1.46fF
C155 VDD_CORE a_825_0# 0.42fF
C156 a_975_n20# a_810_n20# 0.00fF
C157 a_1635_n20# a_1690_n20# 0.02fF
C158 a_920_n20# w_n400_n400# 0.07fF
C159 a_2405_n20# a_2185_n20# 0.00fF
C160 a_2350_n20# a_2240_n20# 0.01fF
C161 a_1030_n20# a_755_n20# 0.00fF
C162 a_975_n20# a_1360_n20# 0.00fF
C163 VDD_1V8 a_2900_n20# 1.46fF
C164 a_260_n20# a_645_n20# 0.00fF
C165 VDD_1V8 a_2350_n20# 1.46fF
C166 a_975_n20# a_1140_n20# 0.00fF
C167 w_n400_n400# a_3065_n20# 0.07fF
C168 a_3010_n20# a_3450_n20# 0.00fF
C169 a_1415_n20# a_1745_n20# 0.00fF
C170 VDD_1V8 a_330_0# 0.42fF
C171 a_1745_n20# a_2075_n20# 0.00fF
C172 a_1910_n20# a_2515_n20# 0.00fF
C173 VDD_CORE a_2515_n20# 1.46fF
C174 a_2130_n20# a_2460_n20# 0.00fF
C175 a_2680_n20# a_2460_n20# 0.00fF
C176 a_150_n20# a_535_n20# 0.00fF
C177 a_2680_n20# a_2790_n20# 0.01fF
C178 a_2020_n20# a_1525_n20# 0.00fF
C179 a_3285_n20# a_3450_n20# 0.00fF
C180 a_3465_0# VDD_CORE 0.42fF
C181 a_2240_n20# a_2625_n20# 0.00fF
C182 VDD_1V8 a_975_n20# 1.46fF
C183 a_865_n20# a_1415_n20# 0.00fF
C184 a_3065_n20# a_2735_n20# 0.00fF
C185 VDD_1V8 a_2625_n20# 1.46fF
C186 w_n400_n400# a_3120_n20# 0.07fF
C187 a_2570_n20# a_2845_n20# 0.00fF
C188 a_2570_n20# a_2075_n20# 0.00fF
C189 VDD_CORE a_260_n20# 1.46fF
C190 a_3065_n20# a_2900_n20# 0.00fF
C191 a_865_n20# a_425_n20# 0.00fF
C192 a_810_n20# a_370_n20# 0.00fF
C193 w_n400_n400# a_95_n20# 0.07fF
C194 a_865_n20# a_315_n20# 0.00fF
C195 a_40_n20# a_95_n20# 0.02fF
C196 a_975_n20# a_920_n20# 0.02fF
C197 a_3120_n20# a_2735_n20# 0.00fF
C198 a_2020_n20# a_1745_n20# 0.00fF
C199 VDD_1V8 a_3230_n20# 1.46fF
C200 a_1030_n20# w_n400_n400# 0.07fF
C201 w_n400_n400# a_755_n20# 0.07fF
C202 a_1415_n20# a_1195_n20# 0.00fF
C203 a_2900_n20# a_3120_n20# 0.00fF
C204 a_700_n20# a_260_n20# 0.00fF
C205 a_1305_n20# a_1525_n20# 0.00fF
C206 a_3065_n20# a_2625_n20# 0.00fF
C207 a_1910_n20# a_2130_n20# 0.00fF
C208 a_2185_n20# a_2515_n20# 0.00fF
C209 VDD_CORE a_2680_n20# 1.46fF
C210 VDD_CORE a_2130_n20# 1.46fF
C211 VDD_1V8 a_370_n20# 1.46fF
C212 a_2020_n20# a_2570_n20# 0.00fF
C213 a_2130_n20# a_1800_n20# 0.00fF
C214 a_2075_n20# a_1855_n20# 0.00fF
C215 a_1415_n20# a_1855_n20# 0.00fF
C216 VDD_1V8 a_3410_0# 0.42fF
C217 a_535_n20# a_590_n20# 0.02fF
C218 a_3010_n20# a_3340_n20# 0.00fF
C219 a_2625_n20# a_3120_n20# 0.00fF
C220 a_2955_n20# a_3450_n20# 0.00fF
C221 a_3230_n20# a_3065_n20# 0.00fF
C222 a_2680_n20# a_3175_n20# 0.00fF
C223 a_1305_n20# a_1745_n20# 0.00fF
C224 VDD_1V8 a_1870_0# 0.42fF
C225 a_920_n20# a_370_n20# 0.00fF
C226 a_2570_n20# a_2460_n20# 0.01fF
C227 a_1910_n20# a_1525_n20# 0.00fF
C228 a_810_n20# a_1415_n20# 0.00fF
C229 VDD_CORE a_1525_n20# 1.46fF
C230 a_3285_n20# a_3340_n20# 0.02fF
C231 a_2570_n20# a_2790_n20# 0.00fF
C232 a_3395_n20# a_3505_n20# 0.01fF
C233 a_975_n20# a_1030_n20# 0.02fF
C234 VDD_CORE a_3505_n20# 1.46fF
C235 a_1415_n20# a_1360_n20# 0.02fF
C236 a_1800_n20# a_1525_n20# 0.00fF
C237 a_975_n20# a_755_n20# 0.00fF
C238 VDD_1V8 a_770_0# 0.42fF
C239 a_865_n20# a_1305_n20# 0.00fF
C240 a_3230_n20# a_3120_n20# 0.01fF
C241 a_865_n20# a_645_n20# 0.00fF
C242 a_1415_n20# a_1140_n20# 0.00fF
C243 w_n400_n400# a_40_n20# 0.07fF
C244 a_810_n20# a_425_n20# 0.00fF
C245 a_2020_n20# a_1855_n20# 0.00fF
C246 a_810_n20# a_315_n20# 0.00fF
C247 a_2845_n20# a_2240_n20# 0.00fF
C248 a_2680_n20# a_2185_n20# 0.00fF
C249 a_2240_n20# a_2075_n20# 0.00fF
C250 a_2405_n20# a_1965_n20# 0.00fF
C251 a_2185_n20# a_2130_n20# 0.02fF
C252 a_3175_n20# a_3505_n20# 0.00fF
C253 VDD_CORE a_385_0# 0.42fF
C254 w_n400_n400# a_2735_n20# 0.07fF
C255 VDD_1V8 a_2845_n20# 1.46fF
C256 a_1910_n20# a_1745_n20# 0.00fF
C257 VDD_1V8 a_2075_n20# 1.46fF
C258 a_260_n20# a_480_n20# 0.00fF
C259 VDD_1V8 a_1415_n20# 1.46fF
C260 VDD_CORE a_1745_n20# 1.46fF
C261 w_n400_n400# a_2900_n20# 0.07fF
C262 a_1745_n20# a_1800_n20# 0.02fF
C263 w_n400_n400# a_2350_n20# 0.07fF
C264 a_1855_n20# a_2460_n20# 0.00fF
C265 a_1525_n20# a_1470_n20# 0.02fF
C266 a_1305_n20# a_1195_n20# 0.01fF
C267 a_95_n20# a_370_n20# 0.00fF
C268 a_1195_n20# a_645_n20# 0.00fF
C269 VDD_1V8 a_425_n20# 1.46fF
C270 a_865_n20# VDD_CORE 1.46fF
C271 a_205_n20# a_260_n20# 0.02fF
C272 VDD_1V8 a_315_n20# 1.46fF
C273 VDD_CORE a_2570_n20# 1.46fF
C274 a_2130_n20# a_1580_n20# 0.00fF
C275 a_2900_n20# a_2735_n20# 0.00fF
C276 a_370_n20# a_755_n20# 0.00fF
C277 a_920_n20# a_1415_n20# 0.00fF
C278 a_975_n20# w_n400_n400# 0.07fF
C279 a_2350_n20# a_2735_n20# 0.00fF
C280 a_1305_n20# a_1855_n20# 0.00fF
C281 a_2020_n20# a_2240_n20# 0.00fF
C282 w_n400_n400# a_2625_n20# 0.07fF
C283 a_2845_n20# a_3065_n20# 0.00fF
C284 a_1085_n20# a_1525_n20# 0.00fF
C285 a_2955_n20# a_3340_n20# 0.00fF
C286 a_2350_n20# a_2900_n20# 0.00fF
C287 a_865_n20# a_700_n20# 0.00fF
C288 a_920_n20# a_425_n20# 0.00fF
C289 VDD_1V8 a_2020_n20# 1.46fF
C290 a_2405_n20# a_2295_n20# 0.01fF
C291 a_2570_n20# a_3175_n20# 0.00fF
C292 a_1745_n20# a_1470_n20# 0.00fF
C293 a_920_n20# a_315_n20# 0.00fF
C294 VDD_CORE a_1195_n20# 1.46fF
C295 a_810_n20# a_1305_n20# 0.00fF
C296 a_1800_n20# a_1195_n20# 0.00fF
C297 a_1580_n20# a_1525_n20# 0.02fF
C298 a_2625_n20# a_2735_n20# 0.01fF
C299 a_1745_n20# a_2185_n20# 0.00fF
C300 a_810_n20# a_645_n20# 0.00fF
C301 a_2845_n20# a_3120_n20# 0.00fF
C302 w_n400_n400# a_3230_n20# 0.07fF
C303 a_865_n20# a_1470_n20# 0.00fF
C304 a_2240_n20# a_2460_n20# 0.00fF
C305 a_1305_n20# a_1360_n20# 0.02fF
C306 VDD_1V8 a_2310_0# 0.42fF
C307 a_2900_n20# a_2625_n20# 0.00fF
C308 a_2790_n20# a_2240_n20# 0.00fF
C309 a_1910_n20# a_1855_n20# 0.02fF
C310 a_1965_n20# a_2515_n20# 0.00fF
C311 VDD_1V8 a_2460_n20# 1.46fF
C312 a_1305_n20# a_1140_n20# 0.00fF
C313 w_n400_n400# m5_0_n220# 2.90fF
C314 VDD_CORE a_1855_n20# 1.46fF
C315 a_2350_n20# a_2625_n20# 0.00fF
C316 a_1140_n20# a_645_n20# 0.00fF
C317 VDD_1V8 a_2790_n20# 1.46fF
C318 a_1195_n20# a_700_n20# 0.00fF
C319 a_1855_n20# a_1800_n20# 0.02fF
C320 VDD_1V8 a_3080_0# 0.42fF
C321 w_n400_n400# a_370_n20# 0.07fF
C322 a_2570_n20# a_2185_n20# 0.00fF
C323 a_3230_n20# a_2735_n20# 0.00fF
C324 VDD_CORE a_1925_0# 0.42fF
C325 a_1030_n20# a_1415_n20# 0.00fF
C326 a_1085_n20# a_865_n20# 0.00fF
C327 a_40_n20# a_370_n20# 0.00fF
C328 VDD_1V8 a_1305_n20# 1.46fF
C329 a_95_n20# a_425_n20# 0.00fF
C330 a_3010_n20# a_3285_n20# 0.00fF
C331 a_1745_n20# a_1580_n20# 0.00fF
C332 a_3230_n20# a_2900_n20# 0.00fF
C333 VDD_1V8 a_645_n20# 1.46fF
C334 a_1195_n20# a_1470_n20# 0.00fF
C335 VDD_CORE a_810_n20# 1.46fF
C336 a_95_n20# a_315_n20# 0.00fF
C337 VDD_CORE a_1155_0# 0.42fF
C338 a_1910_n20# a_1360_n20# 0.00fF
C339 VDD_CORE a_1360_n20# 1.46fF
C340 a_1030_n20# a_425_n20# 0.00fF
C341 a_150_n20# a_260_n20# 0.01fF
C342 a_755_n20# a_425_n20# 0.00fF
C343 a_1800_n20# a_1360_n20# 0.00fF
C344 VDD_CORE a_1140_n20# 1.46fF
C345 a_3065_n20# a_2460_n20# 0.00fF
C346 a_315_n20# a_755_n20# 0.00fF
C347 a_2790_n20# a_3065_n20# 0.00fF
C348 a_1855_n20# a_1470_n20# 0.00fF
C349 a_865_n20# a_480_n20# 0.00fF
C350 a_920_n20# a_1305_n20# 0.00fF
C351 VDD_CORE a_1485_0# 0.42fF
C352 a_920_n20# a_645_n20# 0.00fF
C353 a_810_n20# a_700_n20# 0.01fF
C354 a_2295_n20# a_2515_n20# 0.00fF
C355 a_1910_n20# a_2240_n20# 0.00fF
C356 a_3450_n20# a_3505_n20# 0.02fF
C357 VDD_CORE a_2695_0# 0.42fF
C358 VDD_CORE a_2240_n20# 1.46fF
C359 a_1085_n20# a_1195_n20# 0.01fF
C360 a_3230_n20# a_2625_n20# 0.00fF
C361 VDD_1V8 a_3395_n20# 1.46fF
C362 a_2240_n20# a_1800_n20# 0.00fF
C363 VDD_1V8 a_1910_n20# 1.46fF
C364 a_2185_n20# a_1855_n20# 0.00fF
C365 a_2130_n20# a_1965_n20# 0.00fF
C366 VDD_1V8 VDD_CORE 765.85fF
C367 a_1140_n20# a_700_n20# 0.00fF
C368 VDD_1V8 a_1800_n20# 1.46fF
C369 a_2790_n20# a_3120_n20# 0.00fF
C370 a_1525_n20# a_1250_n20# 0.00fF
C371 a_975_n20# a_370_n20# 0.00fF
C372 a_1580_n20# a_1195_n20# 0.00fF
C373 w_n400_n400# a_2845_n20# 0.07fF
C374 a_1690_n20# a_2130_n20# 0.00fF
C375 w_n400_n400# a_2075_n20# 0.07fF
C376 w_n400_n400# a_1415_n20# 0.07fF
C377 a_1360_n20# a_1470_n20# 0.01fF
C378 VDD_1V8 a_3175_n20# 1.46fF
C379 VDD_1V8 a_700_n20# 1.46fF
C380 a_1140_n20# a_1470_n20# 0.00fF
C381 VDD_CORE a_920_n20# 1.46fF
C382 a_3010_n20# a_2405_n20# 0.00fF
C383 a_1855_n20# a_1580_n20# 0.00fF
C384 a_1965_n20# a_1525_n20# 0.00fF
C385 w_n400_n400# a_425_n20# 0.07fF
C386 a_2955_n20# a_3010_n20# 0.02fF
C387 a_2845_n20# a_2735_n20# 0.01fF
C388 w_n400_n400# a_315_n20# 0.07fF
C389 a_3395_n20# a_3065_n20# 0.00fF
C390 a_40_n20# a_425_n20# 0.00fF
C391 a_1085_n20# a_810_n20# 0.00fF
C392 a_95_n20# a_645_n20# 0.00fF
C393 VDD_CORE a_3065_n20# 1.46fF
C394 a_40_n20# a_315_n20# 0.00fF
C395 VDD_1V8 a_1470_n20# 1.46fF
C396 a_2845_n20# a_2900_n20# 0.02fF
C397 a_1085_n20# a_1360_n20# 0.00fF
C398 a_1745_n20# a_1250_n20# 0.00fF
C399 a_1030_n20# a_1305_n20# 0.00fF
C400 a_2955_n20# a_3285_n20# 0.00fF
C401 a_1690_n20# a_1525_n20# 0.00fF
C402 a_1030_n20# a_645_n20# 0.00fF
C403 a_2845_n20# a_2350_n20# 0.00fF
C404 a_1305_n20# a_755_n20# 0.00fF
C405 a_2680_n20# a_2295_n20# 0.00fF
C406 a_2240_n20# a_2185_n20# 0.02fF
C407 a_2295_n20# a_2130_n20# 0.00fF
C408 a_920_n20# a_700_n20# 0.00fF
C409 a_2350_n20# a_2075_n20# 0.00fF
C410 a_260_n20# a_590_n20# 0.00fF
C411 a_1085_n20# a_1140_n20# 0.02fF
C412 VDD_CORE a_495_0# 0.42fF
C413 a_645_n20# a_755_n20# 0.01fF
C414 VDD_CORE a_3355_0# 0.42fF
C415 VDD_1V8 a_2185_n20# 1.46fF
C416 w_n400_n400# a_2020_n20# 0.07fF
C417 a_865_n20# a_1250_n20# 0.00fF
C418 a_3175_n20# a_3065_n20# 0.01fF
C419 a_3395_n20# a_3120_n20# 0.00fF
C420 a_1580_n20# a_1360_n20# 0.00fF
C421 VDD_CORE a_3120_n20# 1.46fF
C422 a_810_n20# a_480_n20# 0.00fF
C423 a_1745_n20# a_1965_n20# 0.00fF
C424 VDD_CORE a_1595_0# 0.42fF
C425 a_1580_n20# a_1140_n20# 0.00fF
C426 a_920_n20# a_1470_n20# 0.00fF
C427 VDD_1V8 a_1085_n20# 1.46fF
C428 a_975_n20# a_1415_n20# 0.00fF
C429 VDD_CORE a_95_n20# 1.46fF
C430 a_2845_n20# a_2625_n20# 0.00fF
C431 a_3340_n20# a_3505_n20# 0.00fF
C432 a_2075_n20# a_2625_n20# 0.00fF
C433 a_260_n20# a_535_n20# 0.00fF
C434 a_1690_n20# a_1745_n20# 0.02fF
C435 a_1635_n20# a_2130_n20# 0.00fF
C436 a_810_n20# a_205_n20# 0.00fF
C437 a_3175_n20# a_3120_n20# 0.02fF
C438 w_n400_n400# a_2460_n20# 0.07fF
C439 VDD_CORE a_1030_n20# 1.46fF
C440 VDD_CORE a_755_n20# 1.46fF
C441 VDD_1V8 a_1580_n20# 1.46fF
C442 a_975_n20# a_425_n20# 0.00fF
C443 a_2570_n20# a_1965_n20# 0.00fF
C444 VDD_1V8 a_1100_0# 0.42fF
C445 w_n400_n400# a_2790_n20# 0.07fF
C446 a_1250_n20# a_1195_n20# 0.02fF
C447 a_2020_n20# a_2350_n20# 0.00fF
C448 VDD_1V8 a_480_n20# 1.46fF
C449 a_1085_n20# a_920_n20# 0.00fF
C450 a_95_n20# a_700_n20# 0.00fF
C451 a_2845_n20# a_3230_n20# 0.00fF
C452 a_3010_n20# a_2515_n20# 0.00fF
C453 w_n400_n400# a_1305_n20# 0.07fF
C454 a_2460_n20# a_2735_n20# 0.00fF
C455 a_1030_n20# a_700_n20# 0.00fF
C456 w_n400_n400# a_645_n20# 0.07fF
C457 a_2955_n20# a_2405_n20# 0.00fF
C458 a_2790_n20# a_2735_n20# 0.02fF
C459 a_700_n20# a_755_n20# 0.02fF
C460 a_1855_n20# a_1250_n20# 0.00fF
C461 a_1635_n20# a_1525_n20# 0.01fF
C462 a_40_n20# a_645_n20# 0.00fF
C463 a_2900_n20# a_2460_n20# 0.00fF
C464 VDD_1V8 a_205_n20# 1.46fF
C465 VDD_1V8 a_440_0# 0.42fF
C466 a_1745_n20# a_2295_n20# 0.00fF
C467 a_2350_n20# a_2460_n20# 0.01fF
C468 a_2790_n20# a_2900_n20# 0.01fF
C469 a_2020_n20# a_2625_n20# 0.00fF
C470 VDD_1V8 a_3300_0# 0.42fF
C471 a_920_n20# a_480_n20# 0.00fF
C472 a_2790_n20# a_2350_n20# 0.00fF
C473 VDD_CORE a_935_0# 0.42fF
C474 a_1030_n20# a_1470_n20# 0.00fF
C475 a_1690_n20# a_1195_n20# 0.00fF
C476 a_1965_n20# a_1855_n20# 0.01fF
C477 a_370_n20# a_425_n20# 0.02fF
C478 a_810_n20# a_1250_n20# 0.00fF
C479 a_2570_n20# a_2295_n20# 0.00fF
C480 VDD_CORE a_2035_0# 0.42fF
C481 w_n400_n400# a_1910_n20# 0.07fF
C482 w_n400_n400# a_3395_n20# 0.07fF
C483 VDD_CORE w_n400_n400# 85.21fF
C484 a_370_n20# a_315_n20# 0.02fF
C485 a_1360_n20# a_1250_n20# 0.01fF
C486 a_2625_n20# a_2460_n20# 0.00fF
C487 VDD_1V8 a_3450_n20# 1.46fF
C488 a_1635_n20# a_1745_n20# 0.01fF
C489 VDD_CORE a_40_n20# 1.46fF
C490 a_1690_n20# a_1855_n20# 0.00fF
C491 w_n400_n400# a_1800_n20# 0.07fF
C492 a_1250_n20# a_1140_n20# 0.01fF
C493 a_2790_n20# a_2625_n20# 0.00fF
C494 a_1085_n20# a_1030_n20# 0.02fF
C495 a_1085_n20# a_755_n20# 0.00fF
C496 a_3010_n20# a_2680_n20# 0.00fF
C497 a_975_n20# a_1305_n20# 0.00fF
C498 VDD_CORE a_2735_n20# 1.46fF
C499 a_975_n20# a_645_n20# 0.00fF
C500 a_865_n20# a_590_n20# 0.00fF
C501 a_1965_n20# a_1360_n20# 0.00fF
C502 VDD_CORE a_1265_0# 0.42fF
C503 w_n400_n400# a_3175_n20# 0.07fF
C504 w_n400_n400# a_700_n20# 0.07fF
C505 a_3395_n20# a_2900_n20# 0.00fF
C506 a_95_n20# a_480_n20# 0.00fF
C507 VDD_1V8 a_1250_n20# 1.46fF
C508 a_3285_n20# a_2680_n20# 0.00fF
C509 a_1030_n20# a_1580_n20# 0.00fF
C510 VDD_CORE a_2900_n20# 1.46fF
C511 a_2790_n20# a_3230_n20# 0.00fF
C512 a_2405_n20# a_2515_n20# 0.01fF
C513 a_1910_n20# a_2350_n20# 0.00fF
C514 VDD_1V8 a_2200_0# 0.42fF
C515 VDD_CORE a_2350_n20# 1.46fF
C516 a_1690_n20# a_1360_n20# 0.00fF
C517 a_1030_n20# a_480_n20# 0.00fF
C518 a_2350_n20# a_1800_n20# 0.00fF
C519 a_2295_n20# a_1855_n20# 0.00fF
C520 a_2955_n20# a_2515_n20# 0.00fF
C521 a_2240_n20# a_1965_n20# 0.00fF
C522 a_480_n20# a_755_n20# 0.00fF
C523 a_3450_n20# a_3065_n20# 0.00fF
C524 a_3175_n20# a_2735_n20# 0.00fF
C525 w_n400_n400# a_1470_n20# 0.07fF
C526 a_1690_n20# a_1140_n20# 0.00fF
C527 a_205_n20# a_95_n20# 0.01fF
C528 VDD_1V8 a_1965_n20# 1.46fF
C529 a_865_n20# a_535_n20# 0.00fF
C530 a_3175_n20# a_2900_n20# 0.00fF
C531 a_1635_n20# a_1195_n20# 0.00fF
C532 a_920_n20# a_1250_n20# 0.00fF
C533 a_1195_n20# a_590_n20# 0.00fF
C534 a_3010_n20# a_3505_n20# 0.00fF
C535 VDD_1V8 a_150_n20# 1.46fF
C536 a_975_n20# VDD_CORE 1.46fF
C537 a_1690_n20# a_2240_n20# 0.00fF
C538 w_n400_n400# a_2185_n20# 0.07fF
C539 a_205_n20# a_755_n20# 0.00fF
C540 VDD_CORE a_2625_n20# 1.46fF
C541 VDD_1V8 a_1980_0# 0.42fF
C542 VDD_1V8 a_1690_n20# 1.46fF
C543 a_3450_n20# a_3120_n20# 0.00fF
C544 a_3285_n20# a_3505_n20# 0.00fF
C545 a_1085_n20# w_n400_n400# 0.07fF
C546 a_1635_n20# a_1855_n20# 0.00fF
C547 a_645_n20# a_370_n20# 0.00fF
C548 a_315_n20# a_425_n20# 0.01fF
C549 a_2185_n20# a_2735_n20# 0.00fF
C550 a_975_n20# a_700_n20# 0.00fF
C551 a_2020_n20# a_1415_n20# 0.00fF
C552 a_3175_n20# a_2625_n20# 0.00fF
C553 a_2020_n20# a_2075_n20# 0.02fF
C554 a_3230_n20# a_3395_n20# 0.00fF
C555 VDD_CORE a_3230_n20# 1.46fF
C556 VDD_1V8 a_3340_n20# 1.46fF
C557 w_n400_n400# a_1580_n20# 0.07fF
C558 a_2680_n20# a_2405_n20# 0.00fF
C559 a_2405_n20# a_2130_n20# 0.00fF
C560 a_2295_n20# a_2240_n20# 0.02fF
C561 a_2350_n20# a_2185_n20# 0.00fF
C562 VDD_CORE m5_0_n220# 4.14fF
C563 VDD_CORE a_605_0# 0.42fF
C564 w_n400_n400# a_480_n20# 0.07fF
C565 VDD_1V8 a_2295_n20# 1.46fF
C566 a_810_n20# a_590_n20# 0.00fF
C567 a_2955_n20# a_2680_n20# 0.00fF
C568 a_975_n20# a_1470_n20# 0.00fF
C569 a_1635_n20# a_1360_n20# 0.00fF
C570 a_40_n20# a_480_n20# 0.00fF
C571 a_3010_n20# a_2570_n20# 0.00fF
C572 a_3230_n20# a_3175_n20# 0.02fF
C573 VDD_CORE a_370_n20# 1.46fF
C574 a_2845_n20# a_2460_n20# 0.00fF
C575 a_2075_n20# a_2460_n20# 0.00fF
C576 a_1635_n20# a_1140_n20# 0.00fF
C577 a_1030_n20# a_1250_n20# 0.00fF
C578 a_1140_n20# a_590_n20# 0.00fF
C579 a_2790_n20# a_2845_n20# 0.02fF
C580 w_n400_n400# a_205_n20# 0.07fF
C581 a_1250_n20# a_755_n20# 0.00fF
C582 a_2185_n20# a_2625_n20# 0.00fF
C583 a_205_n20# a_40_n20# 0.00fF
C584 a_1635_n20# a_2240_n20# 0.00fF
C585 a_3065_n20# a_3340_n20# 0.00fF
C586 VDD_CORE a_55_0# 0.42fF
C587 a_1085_n20# a_975_n20# 0.01fF
C588 a_810_n20# a_535_n20# 0.00fF
C589 a_1415_n20# a_1305_n20# 0.01fF
C590 a_700_n20# a_370_n20# 0.00fF
C591 VDD_1V8 a_1635_n20# 1.46fF
C592 a_150_n20# a_95_n20# 0.02fF
C593 VDD_1V8 a_590_n20# 1.46fF
C594 VDD_1V8 a_1430_0# 0.42fF
C595 a_2955_n20# a_3505_n20# 0.00fF
C596 a_1140_n20# a_535_n20# 0.00fF
C597 a_150_n20# a_755_n20# 0.00fF
C598 a_975_n20# a_1580_n20# 0.00fF
C599 w_n400_n400# a_3450_n20# 0.07fF
C600 a_3340_n20# a_3120_n20# 0.00fF
C601 a_645_n20# a_425_n20# 0.00fF
C602 a_2020_n20# a_2460_n20# 0.00fF
C603 a_645_n20# a_315_n20# 0.00fF
C604 a_975_n20# a_480_n20# 0.00fF
C605 VDD_1V8 a_550_0# 0.42fF
C606 a_920_n20# a_590_n20# 0.00fF
C607 VDD_1V8 a_535_n20# 1.46fF
C608 a_2845_n20# a_3395_n20# 0.00fF
C609 a_2680_n20# a_2515_n20# 0.00fF
C610 a_2130_n20# a_2515_n20# 0.00fF
C611 VDD_CORE a_2845_n20# 1.46fF
C612 a_1910_n20# a_1415_n20# 0.00fF
C613 a_1910_n20# a_2075_n20# 0.00fF
C614 VDD_CORE a_1415_n20# 1.46fF
C615 VDD_CORE a_2075_n20# 1.46fF
C616 w_n400_n400# a_1250_n20# 0.07fF
C617 a_2075_n20# a_1800_n20# 0.00fF
C618 a_1415_n20# a_1800_n20# 0.00fF
C619 a_3450_n20# a_2900_n20# 0.00fF
C620 a_2570_n20# a_2405_n20# 0.00fF
C621 VDD_CORE a_2145_0# 0.42fF
C622 VDD_CORE a_425_n20# 1.46fF
C623 a_2790_n20# a_2460_n20# 0.00fF
C624 VDD_1V8 a_3520_0# 0.42fF
C625 a_920_n20# a_535_n20# 0.00fF
C626 a_2955_n20# a_2570_n20# 0.00fF
C627 a_2845_n20# a_3175_n20# 0.00fF
C628 VDD_CORE a_315_n20# 1.46fF
C629 w_n400_n400# a_1965_n20# 0.07fF
C630 w_n400_n400# a_150_n20# 0.07fF
C631 a_370_n20# a_480_n20# 0.01fF
C632 a_95_n20# a_590_n20# 0.00fF
C633 a_150_n20# a_40_n20# 0.01fF
C634 a_1690_n20# w_n400_n400# 0.07fF
C635 VDD_1V8 a_3010_n20# 1.46fF
C636 a_700_n20# a_425_n20# 0.00fF
C637 a_1910_n20# a_2020_n20# 0.01fF
C638 VDD_CORE a_2020_n20# 1.46fF
C639 a_1415_n20# a_1470_n20# 0.02fF
C640 a_700_n20# a_315_n20# 0.00fF
C641 a_2075_n20# a_1470_n20# 0.00fF
C642 a_1030_n20# a_1635_n20# 0.00fF
C643 a_2020_n20# a_1800_n20# 0.00fF
C644 a_1030_n20# a_590_n20# 0.00fF
C645 VDD_1V8 a_2750_0# 0.42fF
C646 a_590_n20# a_755_n20# 0.00fF
C647 VDD_1V8 a_3285_n20# 1.46fF
C648 a_205_n20# a_370_n20# 0.00fF
C649 a_2350_n20# a_1965_n20# 0.00fF
C650 a_2185_n20# a_2075_n20# 0.01fF
C651 a_2405_n20# a_1855_n20# 0.00fF
C652 a_2680_n20# a_2130_n20# 0.00fF
C653 a_975_n20# a_1250_n20# 0.00fF
C654 w_n400_n400# a_3340_n20# 0.07fF
C655 a_3450_n20# a_3230_n20# 0.00fF
C656 VDD_1V8 a_990_0# 0.42fF
C657 a_95_n20# a_535_n20# 0.00fF
C658 a_1910_n20# a_2460_n20# 0.00fF
C659 VDD_CORE a_2460_n20# 1.46fF
C660 VDD_1V8 a_110_0# 0.42fF
C661 a_1085_n20# a_1415_n20# 0.00fF
C662 a_2790_n20# a_3395_n20# 0.00fF
C663 w_n400_n400# a_2295_n20# 0.07fF
C664 VDD_CORE a_2790_n20# 1.46fF
C665 w_n400_n400# VGATE 3.43fF
C666 a_1030_n20# a_535_n20# 0.00fF
C667 VDD_1V8 a_2090_0# 0.42fF
C668 a_3010_n20# a_3065_n20# 0.02fF
C669 a_535_n20# a_755_n20# 0.00fF
C670 a_3340_n20# a_2735_n20# 0.00fF
C671 a_2570_n20# a_2515_n20# 0.02fF
C672 a_2020_n20# a_1470_n20# 0.00fF
C673 a_1910_n20# a_1305_n20# 0.00fF
C674 a_2075_n20# a_1580_n20# 0.00fF
C675 a_1415_n20# a_1580_n20# 0.00fF
C676 VDD_CORE a_1305_n20# 1.46fF
C677 a_2130_n20# a_1525_n20# 0.00fF
C678 a_2900_n20# a_3340_n20# 0.00fF
C679 VDD_CORE a_645_n20# 1.46fF
C680 a_3285_n20# a_3065_n20# 0.00fF
C681 a_1305_n20# a_1800_n20# 0.00fF
C682 a_2295_n20# a_2735_n20# 0.00fF
C683 a_2790_n20# a_3175_n20# 0.00fF
C684 a_2020_n20# a_2185_n20# 0.00fF
C685 a_3010_n20# a_3120_n20# 0.01fF
C686 VDD_CORE a_2365_0# 0.42fF
C687 a_2295_n20# a_2900_n20# 0.00fF
C688 a_865_n20# a_260_n20# 0.00fF
C689 a_1635_n20# w_n400_n400# 0.07fF
C690 w_n400_n400# a_590_n20# 0.07fF
C691 a_2405_n20# a_2240_n20# 0.00fF
C692 a_2350_n20# a_2295_n20# 0.02fF
C693 a_1305_n20# a_700_n20# 0.00fF
C694 a_480_n20# a_425_n20# 0.02fF
C695 a_40_n20# a_590_n20# 0.00fF
C696 VDD_1V8 m5_0_3175# 4.14fF
C697 a_3285_n20# a_3120_n20# 0.00fF
C698 a_700_n20# a_645_n20# 0.02fF
C699 VDD_1V8 a_2405_n20# 1.46fF
C700 a_315_n20# a_480_n20# 0.00fF
C701 a_1745_n20# a_2130_n20# 0.00fF
C702 VDD_1V8 a_2955_n20# 1.46fF
C703 a_2185_n20# a_2460_n20# 0.00fF
C704 VDD_CORE a_1910_n20# 1.46fF
C705 VDD_CORE a_3395_n20# 1.46fF
C706 a_2020_n20# a_1580_n20# 0.00fF
C707 a_205_n20# a_425_n20# 0.00fF
C708 a_2790_n20# a_2185_n20# 0.00fF
C709 a_1910_n20# a_1800_n20# 0.01fF
C710 VDD_CORE a_1800_n20# 1.46fF
C711 a_1305_n20# a_1470_n20# 0.00fF
C712 a_2295_n20# a_2625_n20# 0.00fF
C713 w_n400_n400# a_535_n20# 0.07fF
C714 a_205_n20# a_315_n20# 0.01fF
C715 a_150_n20# a_370_n20# 0.00fF
C716 VDD_1V8 a_1210_0# 0.42fF
C717 a_40_n20# a_535_n20# 0.00fF
C718 a_3450_n20# a_2845_n20# 0.00fF
C719 a_2680_n20# a_2570_n20# 0.01fF
C720 a_2570_n20# a_2130_n20# 0.00fF
C721 a_3395_n20# a_3175_n20# 0.00fF
C722 a_3230_n20# a_3340_n20# 0.01fF
C723 VDD_CORE a_3175_n20# 1.46fF
C724 VDD_CORE a_700_n20# 1.46fF
C725 a_1745_n20# a_1525_n20# 0.00fF
C726 a_1085_n20# a_1305_n20# 0.00fF
C727 VDD_CORE a_3245_0# 0.42fF
C728 a_975_n20# a_590_n20# 0.00fF
C729 a_1085_n20# a_645_n20# 0.00fF
C730 a_2955_n20# a_3065_n20# 0.01fF
C731 m5_0_n220# VGATE 2.25fF
C732 a_1910_n20# a_1470_n20# 0.00fF
C733 VDD_CORE a_1470_n20# 1.46fF
C734 a_1415_n20# a_1250_n20# 0.00fF
C735 a_1305_n20# a_1580_n20# 0.00fF
C736 a_1800_n20# a_1470_n20# 0.00fF
C737 a_1910_n20# a_2185_n20# 0.00fF
C738 w_n400_n400# a_3010_n20# 0.07fF
C739 a_810_n20# a_260_n20# 0.00fF
C740 a_2240_n20# a_2515_n20# 0.00fF
C741 VDD_1V8 a_660_0# 0.42fF
C742 VDD_CORE a_2185_n20# 1.46fF
C743 VDD_CORE a_1375_0# 0.42fF
C744 a_2955_n20# a_3120_n20# 0.00fF
C745 a_645_n20# a_480_n20# 0.00fF
C746 VDD_1V8 a_2515_n20# 1.46fF
C747 a_1415_n20# a_1965_n20# 0.00fF
C748 a_2130_n20# a_1855_n20# 0.00fF
C749 a_2075_n20# a_1965_n20# 0.01fF
C750 a_2185_n20# a_1800_n20# 0.00fF
C751 a_975_n20# a_535_n20# 0.00fF
C752 w_n400_n400# a_3285_n20# 0.07fF
C753 a_1085_n20# VDD_CORE 1.46fF
C754 a_1525_n20# a_1195_n20# 0.00fF
C755 a_3010_n20# a_2735_n20# 0.00fF
C756 a_1690_n20# a_2075_n20# 0.00fF
C757 a_1690_n20# a_1415_n20# 0.00fF
C758 a_205_n20# a_645_n20# 0.00fF
C759 a_3010_n20# a_2900_n20# 0.01fF
C760 a_370_n20# a_590_n20# 0.00fF
C761 a_1910_n20# a_1580_n20# 0.00fF
C762 VDD_1V8 a_260_n20# 1.46fF
C763 VDD_CORE a_1580_n20# 1.46fF
C764 a_150_n20# a_425_n20# 0.00fF
C765 a_2805_0# VDD_CORE 0.42fF
C766 a_3285_n20# a_2735_n20# 0.00fF
C767 a_150_n20# a_315_n20# 0.00fF
C768 a_1800_n20# a_1580_n20# 0.00fF
C769 a_1085_n20# a_700_n20# 0.00fF
C770 a_1855_n20# a_1525_n20# 0.00fF
C771 VDD_CORE a_480_n20# 1.46fF
C772 a_3285_n20# a_2900_n20# 0.00fF
C773 VDD_1V8 a_2530_0# 0.42fF
C774 a_2845_n20# a_3340_n20# 0.00fF
C775 a_2515_n20# a_3065_n20# 0.00fF
C776 a_2020_n20# a_1965_n20# 0.02fF
C777 a_1745_n20# a_1195_n20# 0.00fF
C778 VDD_CORE a_3135_0# 0.42fF
C779 VDD_1V8 a_2860_0# 0.42fF
C780 a_2845_n20# a_2295_n20# 0.00fF
C781 a_2680_n20# a_2240_n20# 0.00fF
C782 a_2240_n20# a_2130_n20# 0.01fF
C783 a_370_n20# a_535_n20# 0.00fF
C784 a_2295_n20# a_2075_n20# 0.00fF
C785 VDD_CORE a_205_n20# 1.46fF
C786 a_1085_n20# a_1470_n20# 0.00fF
C787 VDD_CORE a_1705_0# 0.42fF
C788 a_3010_n20# a_2625_n20# 0.00fF
C789 VDD_1V8 a_0_0# 0.42fF
C790 a_700_n20# a_480_n20# 0.00fF
C791 VDD_1V8 a_2680_n20# 1.46fF
C792 VDD_1V8 a_2130_n20# 1.46fF
C793 a_1690_n20# a_2020_n20# 0.00fF
C794 a_865_n20# a_1195_n20# 0.00fF
C795 a_2515_n20# a_3120_n20# 0.00fF
C796 a_1525_n20# a_1360_n20# 0.00fF
C797 a_1745_n20# a_1855_n20# 0.01fF
C798 w_n400_n400# m5_0_3175# 2.90fF
C799 w_n400_n400# a_2405_n20# 0.07fF
C800 a_1305_n20# a_1250_n20# 0.02fF
C801 a_1965_n20# a_2460_n20# 0.00fF
C802 a_1580_n20# a_1470_n20# 0.01fF
C803 a_1525_n20# a_1140_n20# 0.00fF
C804 a_1250_n20# a_645_n20# 0.00fF
C805 w_n400_n400# a_2955_n20# 0.07fF
C806 a_205_n20# a_700_n20# 0.00fF
C807 a_3010_n20# a_3230_n20# 0.00fF
C808 a_3450_n20# a_3395_n20# 0.02fF
C809 VDD_1V8 a_2970_0# 0.42fF
C810 a_1635_n20# a_2075_n20# 0.00fF
C811 VDD_CORE a_3450_n20# 1.46fF
C812 a_1635_n20# a_1415_n20# 0.00fF
C813 a_2185_n20# a_1580_n20# 0.00fF
C814 a_2405_n20# a_2735_n20# 0.00fF
C815 VDD_1V8 a_1525_n20# 1.46fF
C816 a_3285_n20# a_3230_n20# 0.02fF
C817 a_2020_n20# a_2295_n20# 0.00fF
C818 a_1085_n20# a_1580_n20# 0.00fF
C819 VDD_1V8 a_3505_n20# 1.46fF
C820 a_1745_n20# a_1360_n20# 0.00fF
C821 a_2955_n20# a_2735_n20# 0.00fF
C822 a_2680_n20# a_3065_n20# 0.00fF
C823 a_2405_n20# a_2900_n20# 0.00fF
C824 VDD_CORE a_1045_0# 0.42fF
C825 a_95_n20# a_260_n20# 0.00fF
C826 a_150_n20# a_645_n20# 0.00fF
C827 a_590_n20# a_425_n20# 0.00fF
C828 a_2405_n20# a_2350_n20# 0.02fF
C829 a_1745_n20# a_1140_n20# 0.00fF
C830 a_3450_n20# a_3175_n20# 0.00fF
C831 a_315_n20# a_590_n20# 0.00fF
C832 a_1690_n20# a_1305_n20# 0.00fF
C833 a_1085_n20# a_480_n20# 0.00fF
C834 a_2955_n20# a_2900_n20# 0.02fF
C835 a_865_n20# a_810_n20# 0.02fF
C836 VDD_CORE a_1250_n20# 1.46fF
C837 a_2955_n20# a_2350_n20# 0.00fF
C838 a_865_n20# a_1360_n20# 0.00fF
C839 a_260_n20# a_755_n20# 0.00fF
C840 a_2790_n20# a_3340_n20# 0.00fF
C841 a_1800_n20# a_1250_n20# 0.00fF
C842 a_920_n20# a_1525_n20# 0.00fF
C843 a_1745_n20# a_2240_n20# 0.00fF
C844 a_865_n20# a_1140_n20# 0.00fF
C845 a_2295_n20# a_2460_n20# 0.00fF
C846 a_2680_n20# a_3120_n20# 0.00fF
C847 VDD_1V8 a_1745_n20# 1.46fF
C848 VDD_1V8 a_2420_0# 0.42fF
C849 a_1635_n20# a_2020_n20# 0.00fF
C850 a_1910_n20# a_1965_n20# 0.02fF
C851 a_2790_n20# a_2295_n20# 0.00fF
C852 VDD_CORE a_1965_n20# 1.46fF
C853 a_2405_n20# a_2625_n20# 0.00fF
C854 a_535_n20# a_425_n20# 0.01fF
C855 a_1250_n20# a_700_n20# 0.00fF
C856 a_315_n20# a_535_n20# 0.00fF
C857 a_1965_n20# a_1800_n20# 0.00fF
C858 VDD_CORE a_150_n20# 1.46fF
C859 a_3065_n20# a_3505_n20# 0.00fF
C860 a_2955_n20# a_2625_n20# 0.00fF
C861 a_810_n20# a_1195_n20# 0.00fF
C862 VDD_1V8 a_865_n20# 1.46fF
C863 a_2570_n20# a_2240_n20# 0.00fF
C864 a_1690_n20# a_1910_n20# 0.00fF
C865 w_n400_n400# a_2515_n20# 0.07fF
C866 VDD_CORE a_2475_0# 0.42fF
C867 VDD_CORE a_1690_n20# 1.46fF
C868 a_1360_n20# a_1195_n20# 0.00fF
C869 VDD_1V8 a_2570_n20# 1.46fF
C870 a_205_n20# a_480_n20# 0.00fF
C871 a_1690_n20# a_1800_n20# 0.01fF
C872 a_1195_n20# a_1140_n20# 0.02fF
C873 a_1250_n20# a_1470_n20# 0.00fF
C874 a_3120_n20# a_3505_n20# 0.00fF
C875 a_3010_n20# a_2845_n20# 0.00fF
C876 a_150_n20# a_700_n20# 0.00fF
C877 a_2955_n20# a_3230_n20# 0.00fF
C878 a_865_n20# a_920_n20# 0.02fF
C879 a_3395_n20# a_3340_n20# 0.02fF
C880 a_2515_n20# a_2735_n20# 0.00fF
C881 VDD_CORE a_3340_n20# 1.46fF
C882 a_1855_n20# a_1360_n20# 0.00fF
C883 w_n400_n400# a_260_n20# 0.07fF
C884 a_1635_n20# a_1305_n20# 0.00fF
C885 a_2515_n20# a_2900_n20# 0.00fF
C886 a_1965_n20# a_1470_n20# 0.00fF
C887 a_3285_n20# a_2845_n20# 0.00fF
C888 VDD_1V8 a_1195_n20# 1.46fF
C889 a_1030_n20# a_1525_n20# 0.00fF
C890 a_40_n20# a_260_n20# 0.00fF
C891 a_645_n20# a_590_n20# 0.02fF
C892 a_2350_n20# a_2515_n20# 0.00fF
C893 a_1910_n20# a_2295_n20# 0.00fF
C894 VDD_CORE a_2295_n20# 1.46fF
C895 VDD_CORE VGATE 3.02fF
C896 a_1085_n20# a_1250_n20# 0.00fF
C897 VDD_1V8 a_1320_0# 0.42fF
C898 a_2295_n20# a_1800_n20# 0.00fF
C899 a_2240_n20# a_1855_n20# 0.00fF
C900 a_2185_n20# a_1965_n20# 0.00fF
C901 VDD_CORE a_275_0# 0.42fF
C902 a_2570_n20# a_3065_n20# 0.00fF
C903 a_3175_n20# a_3340_n20# 0.00fF
C904 a_1690_n20# a_1470_n20# 0.00fF
C905 w_n400_n400# $SUB 205.36fF
