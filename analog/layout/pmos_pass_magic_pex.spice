* NGSPICE file created from pmos_pass_2000u.ext - technology: sky130A

.global w<0.42 a1<0.47 a1<11.57 a1<2.01 a1<1.01

* Top level circuit pmos_pass_2000u

X0 a_385_0# a_370_n20# a_330_0# w_n400_n400# sky130_fd_pr__pfet_01v8 ad=1.25e+13p pd=6.33e+07u as=1.25e+13p ps=6.33e+07u w=3.125e+07u l=150000u
X1 a_605_0# a_590_n20# a_550_0# w_n400_n400# sky130_fd_pr__pfet_01v8 ad=1.25e+13p pd=6.33e+07u as=1.25e+13p ps=6.33e+07u w=3.125e+07u l=150000u
X2 a_2420_0# a_2405_n20# a_2365_0# w_n400_n400# sky130_fd_pr__pfet_01v8 ad=1.25e+13p pd=6.33e+07u as=1.25e+13p ps=6.33e+07u w=3.125e+07u l=150000u
X3 a_1430_0# a_1415_n20# a_1375_0# w_n400_n400# sky130_fd_pr__pfet_01v8 ad=1.25e+13p pd=6.33e+07u as=1.25e+13p ps=6.33e+07u w=3.125e+07u l=150000u
X4 a_2640_0# a_2625_n20# a_2585_0# w_n400_n400# sky130_fd_pr__pfet_01v8 ad=1.25e+13p pd=6.33e+07u as=1.25e+13p ps=6.33e+07u w=3.125e+07u l=150000u
X5 a_1650_0# a_1635_n20# a_1595_0# w_n400_n400# sky130_fd_pr__pfet_01v8 ad=1.25e+13p pd=6.33e+07u as=1.25e+13p ps=6.33e+07u w=3.125e+07u l=150000u
X6 a_1815_0# a_1800_n20# a_1760_0# w_n400_n400# sky130_fd_pr__pfet_01v8 ad=1.25e+13p pd=6.33e+07u as=1.25e+13p ps=6.33e+07u w=3.125e+07u l=150000u
X7 a_2860_0# a_2845_n20# a_2805_0# w_n400_n400# sky130_fd_pr__pfet_01v8 ad=1.25e+13p pd=6.33e+07u as=1.25e+13p ps=6.33e+07u w=3.125e+07u l=150000u
X8 a_1870_0# a_1855_n20# a_1815_0# w_n400_n400# sky130_fd_pr__pfet_01v8 ad=1.25e+13p pd=6.33e+07u as=0p ps=0u w=3.125e+07u l=150000u
X9 a_3135_0# a_3120_n20# a_3080_0# w_n400_n400# sky130_fd_pr__pfet_01v8 ad=1.25e+13p pd=6.33e+07u as=1.25e+13p ps=6.33e+07u w=3.125e+07u l=150000u
X10 a_2145_0# a_2130_n20# a_2090_0# w_n400_n400# sky130_fd_pr__pfet_01v8 ad=1.25e+13p pd=6.33e+07u as=1.25e+13p ps=6.33e+07u w=3.125e+07u l=150000u
X11 a_3190_0# a_3175_n20# a_3135_0# w_n400_n400# sky130_fd_pr__pfet_01v8 ad=1.25e+13p pd=6.33e+07u as=0p ps=0u w=3.125e+07u l=150000u
X12 a_3355_0# a_3340_n20# a_3300_0# w_n400_n400# sky130_fd_pr__pfet_01v8 ad=1.25e+13p pd=6.33e+07u as=1.25e+13p ps=6.33e+07u w=3.125e+07u l=150000u
X13 a_1155_0# a_1140_n20# a_1100_0# w_n400_n400# sky130_fd_pr__pfet_01v8 ad=1.25e+13p pd=6.33e+07u as=1.25e+13p ps=6.33e+07u w=3.125e+07u l=150000u
X14 a_2200_0# a_2185_n20# a_2145_0# w_n400_n400# sky130_fd_pr__pfet_01v8 ad=1.25e+13p pd=6.33e+07u as=0p ps=0u w=3.125e+07u l=150000u
X15 a_2365_0# a_2350_n20# a_2310_0# w_n400_n400# sky130_fd_pr__pfet_01v8 ad=0p pd=0u as=1.25e+13p ps=6.33e+07u w=3.125e+07u l=150000u
X16 a_3410_0# a_3395_n20# a_3355_0# w_n400_n400# sky130_fd_pr__pfet_01v8 ad=1.25e+13p pd=6.33e+07u as=0p ps=0u w=3.125e+07u l=150000u
X17 a_330_0# a_315_n20# a_275_0# w_n400_n400# sky130_fd_pr__pfet_01v8 ad=0p pd=0u as=1.25e+13p ps=6.33e+07u w=3.125e+07u l=150000u
X18 a_1210_0# a_1195_n20# a_1155_0# w_n400_n400# sky130_fd_pr__pfet_01v8 ad=1.25e+13p pd=6.33e+07u as=0p ps=0u w=3.125e+07u l=150000u
X19 a_1375_0# a_1360_n20# a_1320_0# w_n400_n400# sky130_fd_pr__pfet_01v8 ad=0p pd=0u as=1.25e+13p ps=6.33e+07u w=3.125e+07u l=150000u
X20 a_2585_0# a_2570_n20# a_2530_0# w_n400_n400# sky130_fd_pr__pfet_01v8 ad=0p pd=0u as=1.25e+13p ps=6.33e+07u w=3.125e+07u l=150000u
X21 a_550_0# a_535_n20# a_495_0# w_n400_n400# sky130_fd_pr__pfet_01v8 ad=0p pd=0u as=1.25e+13p ps=6.33e+07u w=3.125e+07u l=150000u
X22 a_715_0# a_700_n20# a_660_0# w_n400_n400# sky130_fd_pr__pfet_01v8 ad=1.25e+13p pd=6.33e+07u as=1.25e+13p ps=6.33e+07u w=3.125e+07u l=150000u
X23 a_1595_0# a_1580_n20# a_1540_0# w_n400_n400# sky130_fd_pr__pfet_01v8 ad=0p pd=0u as=1.25e+13p ps=6.33e+07u w=3.125e+07u l=150000u
X24 a_2805_0# a_2790_n20# a_2750_0# w_n400_n400# sky130_fd_pr__pfet_01v8 ad=0p pd=0u as=1.25e+13p ps=6.33e+07u w=3.125e+07u l=150000u
X25 a_770_0# a_755_n20# a_715_0# w_n400_n400# sky130_fd_pr__pfet_01v8 ad=1.25e+13p pd=6.33e+07u as=0p ps=0u w=3.125e+07u l=150000u
X26 a_935_0# a_920_n20# a_880_0# w_n400_n400# sky130_fd_pr__pfet_01v8 ad=1.25e+13p pd=6.33e+07u as=1.25e+13p ps=6.33e+07u w=3.125e+07u l=150000u
X27 a_990_0# a_975_n20# a_935_0# w_n400_n400# sky130_fd_pr__pfet_01v8 ad=1.25e+13p pd=6.33e+07u as=0p ps=0u w=3.125e+07u l=150000u
X28 a_55_0# a_40_n20# a_0_0# w_n400_n400# sky130_fd_pr__pfet_01v8 ad=1.25e+13p pd=6.33e+07u as=1.25e+13p ps=6.33e+07u w=3.125e+07u l=150000u
X29 a_275_0# a_260_n20# a_220_0# w_n400_n400# sky130_fd_pr__pfet_01v8 ad=0p pd=0u as=1.25e+13p ps=6.33e+07u w=3.125e+07u l=150000u
X30 a_110_0# a_95_n20# a_55_0# w_n400_n400# sky130_fd_pr__pfet_01v8 ad=1.25e+13p pd=6.33e+07u as=0p ps=0u w=3.125e+07u l=150000u
X31 a_495_0# a_480_n20# a_440_0# w_n400_n400# sky130_fd_pr__pfet_01v8 ad=0p pd=0u as=1.25e+13p ps=6.33e+07u w=3.125e+07u l=150000u
X32 a_3520_0# a_3505_n20# a_3465_0# w_n400_n400# sky130_fd_pr__pfet_01v8 ad=1.25e+13p pd=6.33e+07u as=1.25e+13p ps=6.33e+07u w=3.125e+07u l=150000u
X33 a_1320_0# a_1305_n20# a_1265_0# w_n400_n400# sky130_fd_pr__pfet_01v8 ad=0p pd=0u as=1.25e+13p ps=6.33e+07u w=3.125e+07u l=150000u
X34 a_2530_0# a_2515_n20# a_2475_0# w_n400_n400# sky130_fd_pr__pfet_01v8 ad=0p pd=0u as=1.25e+13p ps=6.33e+07u w=3.125e+07u l=150000u
X35 a_1540_0# a_1525_n20# a_1485_0# w_n400_n400# sky130_fd_pr__pfet_01v8 ad=0p pd=0u as=1.25e+13p ps=6.33e+07u w=3.125e+07u l=150000u
X36 a_2750_0# a_2735_n20# a_2695_0# w_n400_n400# sky130_fd_pr__pfet_01v8 ad=0p pd=0u as=1.25e+13p ps=6.33e+07u w=3.125e+07u l=150000u
X37 a_2915_0# a_2900_n20# a_2860_0# w_n400_n400# sky130_fd_pr__pfet_01v8 ad=1.25e+13p pd=6.33e+07u as=0p ps=0u w=3.125e+07u l=150000u
X38 a_1760_0# a_1745_n20# a_1705_0# w_n400_n400# sky130_fd_pr__pfet_01v8 ad=0p pd=0u as=1.25e+13p ps=6.33e+07u w=3.125e+07u l=150000u
X39 a_1925_0# a_1910_n20# a_1870_0# w_n400_n400# sky130_fd_pr__pfet_01v8 ad=1.25e+13p pd=6.33e+07u as=0p ps=0u w=3.125e+07u l=150000u
X40 a_2970_0# a_2955_n20# a_2915_0# w_n400_n400# sky130_fd_pr__pfet_01v8 ad=1.25e+13p pd=6.33e+07u as=0p ps=0u w=3.125e+07u l=150000u
X41 a_1980_0# a_1965_n20# a_1925_0# w_n400_n400# sky130_fd_pr__pfet_01v8 ad=1.25e+13p pd=6.33e+07u as=0p ps=0u w=3.125e+07u l=150000u
X42 a_3025_0# a_3010_n20# a_2970_0# w_n400_n400# sky130_fd_pr__pfet_01v8 ad=1.25e+13p pd=6.33e+07u as=0p ps=0u w=3.125e+07u l=150000u
X43 a_2035_0# a_2020_n20# a_1980_0# w_n400_n400# sky130_fd_pr__pfet_01v8 ad=1.25e+13p pd=6.33e+07u as=0p ps=0u w=3.125e+07u l=150000u
X44 a_3245_0# a_3230_n20# a_3190_0# w_n400_n400# sky130_fd_pr__pfet_01v8 ad=1.25e+13p pd=6.33e+07u as=0p ps=0u w=3.125e+07u l=150000u
X45 a_1045_0# a_1030_n20# a_990_0# w_n400_n400# sky130_fd_pr__pfet_01v8 ad=1.25e+13p pd=6.33e+07u as=0p ps=0u w=3.125e+07u l=150000u
X46 a_2255_0# a_2240_n20# a_2200_0# w_n400_n400# sky130_fd_pr__pfet_01v8 ad=1.25e+13p pd=6.33e+07u as=0p ps=0u w=3.125e+07u l=150000u
X47 a_3080_0# a_3065_n20# a_3025_0# w_n400_n400# sky130_fd_pr__pfet_01v8 ad=0p pd=0u as=0p ps=0u w=3.125e+07u l=150000u
X48 a_2090_0# a_2075_n20# a_2035_0# w_n400_n400# sky130_fd_pr__pfet_01v8 ad=0p pd=0u as=0p ps=0u w=3.125e+07u l=150000u
X49 a_3300_0# a_3285_n20# a_3245_0# w_n400_n400# sky130_fd_pr__pfet_01v8 ad=0p pd=0u as=0p ps=0u w=3.125e+07u l=150000u
X50 a_3465_0# a_3450_n20# a_3410_0# w_n400_n400# sky130_fd_pr__pfet_01v8 ad=0p pd=0u as=0p ps=0u w=3.125e+07u l=150000u
X51 a_220_0# a_205_n20# a_165_0# w_n400_n400# sky130_fd_pr__pfet_01v8 ad=0p pd=0u as=1.25e+13p ps=6.33e+07u w=3.125e+07u l=150000u
X52 a_1100_0# a_1085_n20# a_1045_0# w_n400_n400# sky130_fd_pr__pfet_01v8 ad=0p pd=0u as=0p ps=0u w=3.125e+07u l=150000u
X53 a_1265_0# a_1250_n20# a_1210_0# w_n400_n400# sky130_fd_pr__pfet_01v8 ad=0p pd=0u as=0p ps=0u w=3.125e+07u l=150000u
X54 a_2310_0# a_2295_n20# a_2255_0# w_n400_n400# sky130_fd_pr__pfet_01v8 ad=0p pd=0u as=0p ps=0u w=3.125e+07u l=150000u
X55 a_2475_0# a_2460_n20# a_2420_0# w_n400_n400# sky130_fd_pr__pfet_01v8 ad=0p pd=0u as=0p ps=0u w=3.125e+07u l=150000u
X56 a_440_0# a_425_n20# a_385_0# w_n400_n400# sky130_fd_pr__pfet_01v8 ad=0p pd=0u as=0p ps=0u w=3.125e+07u l=150000u
X57 a_1485_0# a_1470_n20# a_1430_0# w_n400_n400# sky130_fd_pr__pfet_01v8 ad=0p pd=0u as=0p ps=0u w=3.125e+07u l=150000u
X58 a_2695_0# a_2680_n20# a_2640_0# w_n400_n400# sky130_fd_pr__pfet_01v8 ad=0p pd=0u as=0p ps=0u w=3.125e+07u l=150000u
X59 a_660_0# a_645_n20# a_605_0# w_n400_n400# sky130_fd_pr__pfet_01v8 ad=0p pd=0u as=0p ps=0u w=3.125e+07u l=150000u
X60 a_825_0# a_810_n20# a_770_0# w_n400_n400# sky130_fd_pr__pfet_01v8 ad=1.25e+13p pd=6.33e+07u as=0p ps=0u w=3.125e+07u l=150000u
X61 a_1705_0# a_1690_n20# a_1650_0# w_n400_n400# sky130_fd_pr__pfet_01v8 ad=0p pd=0u as=0p ps=0u w=3.125e+07u l=150000u
X62 a_880_0# a_865_n20# a_825_0# w_n400_n400# sky130_fd_pr__pfet_01v8 ad=0p pd=0u as=0p ps=0u w=3.125e+07u l=150000u
X63 a_165_0# a_150_n20# a_110_0# w_n400_n400# sky130_fd_pr__pfet_01v8 ad=0p pd=0u as=0p ps=0u w=3.125e+07u l=150000u
C0 a_755_n20# a_315_n20# 0.00fF
C1 w_n400_n400# a_1580_n20# 0.07fF
C2 a_1250_n20# a_920_n20# 0.00fF
C3 VDD_CORE a_2805_0# 0.42fF
C4 a_1525_n20# a_2130_n20# 0.00fF
C5 a_1085_n20# a_1305_n20# 0.00fF
C6 VDD_CORE a_2405_n20# 1.46fF
C7 a_2625_n20# a_2570_n20# 0.02fF
C8 a_2680_n20# a_2515_n20# 0.00fF
C9 a_2295_n20# a_2405_n20# 0.01fF
C10 a_260_n20# a_590_n20# 0.00fF
C11 a_1305_n20# a_975_n20# 0.00fF
C12 VDD_CORE a_2570_n20# 1.46fF
C13 a_2075_n20# a_2460_n20# 0.00fF
C14 a_2570_n20# a_2295_n20# 0.00fF
C15 a_2680_n20# a_2130_n20# 0.00fF
C16 a_2625_n20# a_2185_n20# 0.00fF
C17 a_315_n20# a_480_n20# 0.00fF
C18 a_1470_n20# a_1855_n20# 0.00fF
C19 a_150_n20# w_n400_n400# 0.07fF
C20 a_95_n20# a_370_n20# 0.00fF
C21 VDD_CORE a_2185_n20# 1.46fF
C22 a_2295_n20# a_2185_n20# 0.01fF
C23 w_n400_n400# a_3505_n20# 0.07fF
C24 a_1360_n20# a_1855_n20# 0.00fF
C25 a_865_n20# a_1085_n20# 0.00fF
C26 w_n400_n400# a_3010_n20# 0.07fF
C27 a_40_n20# VDD_1V8 1.46fF
C28 VDD_CORE a_2915_0# 0.42fF
C29 a_2075_n20# a_1800_n20# 0.00fF
C30 a_2020_n20# a_1855_n20# 0.00fF
C31 VDD_CORE a_1265_0# 0.42fF
C32 a_1470_n20# w_n400_n400# 0.07fF
C33 a_865_n20# a_975_n20# 0.01fF
C34 a_2075_n20# a_1635_n20# 0.00fF
C35 a_1250_n20# a_1580_n20# 0.00fF
C36 a_3340_n20# a_3120_n20# 0.00fF
C37 w_n400_n400# a_1360_n20# 0.07fF
C38 a_755_n20# a_1140_n20# 0.00fF
C39 w_n400_n400# a_2020_n20# 0.07fF
C40 a_1415_n20# a_1800_n20# 0.00fF
C41 a_1525_n20# a_1745_n20# 0.00fF
C42 a_590_n20# w_n400_n400# 0.07fF
C43 a_3175_n20# a_2845_n20# 0.00fF
C44 a_3230_n20# a_2790_n20# 0.00fF
C45 a_95_n20# a_645_n20# 0.00fF
C46 a_3120_n20# a_2955_n20# 0.00fF
C47 VDD_1V8 a_2515_n20# 1.46fF
C48 a_920_n20# a_1470_n20# 0.00fF
C49 a_1415_n20# a_1635_n20# 0.00fF
C50 a_1030_n20# a_1635_n20# 0.00fF
C51 VDD_CORE a_205_n20# 1.46fF
C52 a_1140_n20# a_1525_n20# 0.00fF
C53 a_2900_n20# a_2460_n20# 0.00fF
C54 a_2790_n20# a_2735_n20# 0.02fF
C55 a_3065_n20# a_2570_n20# 0.00fF
C56 a_2955_n20# a_2680_n20# 0.00fF
C57 a_260_n20# a_865_n20# 0.00fF
C58 a_920_n20# a_1360_n20# 0.00fF
C59 VDD_1V8 a_2130_n20# 1.46fF
C60 a_1305_n20# a_1855_n20# 0.00fF
C61 a_755_n20# a_700_n20# 0.02fF
C62 a_535_n20# a_205_n20# 0.00fF
C63 a_315_n20# a_40_n20# 0.00fF
C64 a_920_n20# a_590_n20# 0.00fF
C65 VDD_1V8 a_2530_0# 0.42fF
C66 a_2075_n20# a_2405_n20# 0.00fF
C67 VDD_CORE a_2475_0# 0.42fF
C68 a_1250_n20# a_1470_n20# 0.00fF
C69 a_315_n20# VDD_1V8 1.46fF
C70 VDD_1V8 a_1210_0# 0.42fF
C71 a_810_n20# a_205_n20# 0.00fF
C72 a_1965_n20# a_2460_n20# 0.00fF
C73 a_2570_n20# a_2075_n20# 0.00fF
C74 a_480_n20# a_700_n20# 0.00fF
C75 a_2515_n20# a_2130_n20# 0.00fF
C76 a_1250_n20# a_1360_n20# 0.01fF
C77 a_1305_n20# w_n400_n400# 0.07fF
C78 VDD_CORE a_3025_0# 0.42fF
C79 a_2240_n20# a_2020_n20# 0.00fF
C80 a_1525_n20# a_1690_n20# 0.00fF
C81 a_2185_n20# a_2075_n20# 0.01fF
C82 a_755_n20# a_425_n20# 0.00fF
C83 a_1470_n20# a_1580_n20# 0.01fF
C84 VDD_1V8 a_1540_0# 0.42fF
C85 w_n400_n400# a_2845_n20# 0.07fF
C86 a_1965_n20# a_1800_n20# 0.00fF
C87 VDD_CORE a_1195_n20# 1.46fF
C88 VDD_1V8 a_2750_0# 0.42fF
C89 a_920_n20# a_1305_n20# 0.00fF
C90 a_1360_n20# a_1580_n20# 0.00fF
C91 a_370_n20# a_205_n20# 0.00fF
C92 VDD_1V8 a_3340_n20# 1.46fF
C93 a_2790_n20# a_2350_n20# 0.00fF
C94 a_1965_n20# a_1635_n20# 0.00fF
C95 a_865_n20# w_n400_n400# 0.07fF
C96 a_425_n20# a_480_n20# 0.02fF
C97 a_3230_n20# a_3120_n20# 0.01fF
C98 a_2020_n20# a_1580_n20# 0.00fF
C99 a_1085_n20# a_1635_n20# 0.00fF
C100 a_1745_n20# VDD_1V8 1.46fF
C101 VDD_1V8 a_2955_n20# 1.46fF
C102 a_3505_n20# a_3010_n20# 0.00fF
C103 VDD_CORE a_1925_0# 0.42fF
C104 a_3230_n20# a_2680_n20# 0.00fF
C105 a_3120_n20# a_2735_n20# 0.00fF
C106 VDD_CORE a_275_0# 0.42fF
C107 w_n400_n400# VGATE 3.43fF
C108 a_810_n20# a_1195_n20# 0.00fF
C109 a_1250_n20# a_1305_n20# 0.02fF
C110 a_1140_n20# VDD_1V8 1.46fF
C111 a_2900_n20# a_2405_n20# 0.00fF
C112 a_590_n20# a_150_n20# 0.00fF
C113 a_865_n20# a_920_n20# 0.02fF
C114 VDD_1V8 a_1650_0# 0.42fF
C115 a_2900_n20# a_2570_n20# 0.00fF
C116 a_2790_n20# a_2625_n20# 0.00fF
C117 a_2955_n20# a_2515_n20# 0.00fF
C118 a_2735_n20# a_2680_n20# 0.02fF
C119 a_1470_n20# a_1360_n20# 0.01fF
C120 VDD_CORE a_2790_n20# 1.46fF
C121 a_1525_n20# a_1910_n20# 0.00fF
C122 a_645_n20# a_205_n20# 0.00fF
C123 a_1745_n20# a_2130_n20# 0.00fF
C124 a_2790_n20# a_2295_n20# 0.00fF
C125 a_2845_n20# a_2240_n20# 0.00fF
C126 a_1965_n20# a_2405_n20# 0.00fF
C127 a_1470_n20# a_2020_n20# 0.00fF
C128 a_1305_n20# a_1580_n20# 0.00fF
C129 VDD_1V8 a_440_0# 0.42fF
C130 VDD_1V8 a_700_n20# 1.46fF
C131 a_1250_n20# a_865_n20# 0.00fF
C132 a_1855_n20# a_2460_n20# 0.00fF
C133 a_2570_n20# a_1965_n20# 0.00fF
C134 a_1690_n20# VDD_1V8 1.46fF
C135 a_260_n20# a_95_n20# 0.00fF
C136 a_2185_n20# a_1965_n20# 0.00fF
C137 VDD_CORE a_2695_0# 0.42fF
C138 a_40_n20# a_425_n20# 0.00fF
C139 w_n400_n400# a_2460_n20# 0.07fF
C140 VDD_1V8 a_220_0# 0.42fF
C141 a_3450_n20# a_3120_n20# 0.00fF
C142 a_1855_n20# a_1800_n20# 0.02fF
C143 VDD_1V8 a_3230_n20# 1.46fF
C144 a_425_n20# VDD_1V8 1.46fF
C145 a_2680_n20# a_2350_n20# 0.00fF
C146 a_1855_n20# a_1635_n20# 0.00fF
C147 a_1305_n20# a_1470_n20# 0.00fF
C148 a_755_n20# VDD_CORE 1.46fF
C149 a_3340_n20# a_2955_n20# 0.00fF
C150 a_1690_n20# a_2130_n20# 0.00fF
C151 a_645_n20# a_1195_n20# 0.00fF
C152 VDD_CORE a_385_0# 0.42fF
C153 VDD_1V8 a_2735_n20# 1.46fF
C154 a_1305_n20# a_1360_n20# 0.02fF
C155 a_315_n20# a_700_n20# 0.00fF
C156 w_n400_n400# a_1800_n20# 0.07fF
C157 a_3010_n20# a_2845_n20# 0.00fF
C158 a_755_n20# a_535_n20# 0.00fF
C159 a_3065_n20# a_2790_n20# 0.00fF
C160 a_1415_n20# a_1195_n20# 0.00fF
C161 a_3175_n20# a_2570_n20# 0.00fF
C162 a_3120_n20# a_2625_n20# 0.00fF
C163 a_1030_n20# a_1195_n20# 0.00fF
C164 VDD_CORE a_55_0# 0.42fF
C165 VDD_CORE a_480_n20# 1.46fF
C166 VDD_CORE a_3355_0# 0.42fF
C167 w_n400_n400# a_1635_n20# 0.07fF
C168 a_1525_n20# VDD_CORE 1.46fF
C169 VDD_CORE a_3120_n20# 1.46fF
C170 a_1140_n20# a_1745_n20# 0.00fF
C171 a_95_n20# w_n400_n400# 0.07fF
C172 a_2735_n20# a_2515_n20# 0.00fF
C173 a_2680_n20# a_2625_n20# 0.02fF
C174 a_755_n20# a_810_n20# 0.02fF
C175 a_865_n20# a_1470_n20# 0.00fF
C176 VDD_1V8 a_1910_n20# 1.46fF
C177 a_535_n20# a_480_n20# 0.02fF
C178 VDD_CORE a_2680_n20# 1.46fF
C179 a_2240_n20# a_2460_n20# 0.00fF
C180 a_2735_n20# a_2130_n20# 0.00fF
C181 a_2680_n20# a_2295_n20# 0.00fF
C182 a_865_n20# a_1360_n20# 0.00fF
C183 a_1855_n20# a_2405_n20# 0.00fF
C184 a_315_n20# a_425_n20# 0.01fF
C185 a_810_n20# a_480_n20# 0.00fF
C186 VDD_1V8 a_1870_0# 0.42fF
C187 a_865_n20# a_590_n20# 0.00fF
C188 a_2515_n20# a_1910_n20# 0.00fF
C189 a_755_n20# a_370_n20# 0.00fF
C190 VDD_1V8 a_2350_n20# 1.46fF
C191 a_1250_n20# a_1800_n20# 0.00fF
C192 a_2185_n20# a_1855_n20# 0.00fF
C193 a_2130_n20# a_1910_n20# 0.00fF
C194 a_1690_n20# a_1745_n20# 0.02fF
C195 a_2240_n20# a_1800_n20# 0.00fF
C196 VDD_1V8 a_3450_n20# 1.46fF
C197 w_n400_n400# a_2405_n20# 0.07fF
C198 a_1140_n20# a_700_n20# 0.00fF
C199 a_2240_n20# a_1635_n20# 0.00fF
C200 a_1250_n20# a_1635_n20# 0.00fF
C201 w_n400_n400# a_2570_n20# 0.07fF
C202 a_1140_n20# a_1690_n20# 0.00fF
C203 a_3340_n20# a_3230_n20# 0.01fF
C204 a_260_n20# a_205_n20# 0.02fF
C205 a_370_n20# a_480_n20# 0.01fF
C206 VDD_CORE a_935_0# 0.42fF
C207 a_2515_n20# a_2350_n20# 0.00fF
C208 a_1085_n20# a_1195_n20# 0.01fF
C209 w_n400_n400# a_2185_n20# 0.07fF
C210 a_1800_n20# a_1580_n20# 0.00fF
C211 a_3340_n20# a_2735_n20# 0.00fF
C212 a_3230_n20# a_2955_n20# 0.00fF
C213 a_3120_n20# a_3065_n20# 0.02fF
C214 a_3285_n20# a_2790_n20# 0.00fF
C215 VDD_1V8 a_3190_0# 0.42fF
C216 a_40_n20# VDD_CORE 1.46fF
C217 a_865_n20# a_1305_n20# 0.00fF
C218 VDD_1V8 a_2625_n20# 1.46fF
C219 a_3395_n20# a_2790_n20# 0.00fF
C220 a_2130_n20# a_2350_n20# 0.00fF
C221 a_975_n20# a_1195_n20# 0.00fF
C222 a_1580_n20# a_1635_n20# 0.02fF
C223 a_3010_n20# a_2460_n20# 0.00fF
C224 a_3065_n20# a_2680_n20# 0.00fF
C225 a_2900_n20# a_2790_n20# 0.01fF
C226 a_2955_n20# a_2735_n20# 0.00fF
C227 VDD_CORE VDD_1V8 765.85fF
C228 a_755_n20# a_645_n20# 0.01fF
C229 a_40_n20# a_535_n20# 0.00fF
C230 VDD_1V8 a_2295_n20# 1.46fF
C231 a_1525_n20# a_2075_n20# 0.00fF
C232 a_3410_0# VDD_1V8 0.42fF
C233 a_2625_n20# a_2515_n20# 0.01fF
C234 a_755_n20# a_1030_n20# 0.00fF
C235 a_535_n20# VDD_1V8 1.46fF
C236 a_2240_n20# a_2405_n20# 0.00fF
C237 a_480_n20# a_645_n20# 0.00fF
C238 VDD_CORE a_2515_n20# 1.46fF
C239 a_150_n20# a_95_n20# 0.02fF
C240 a_2020_n20# a_2460_n20# 0.00fF
C241 a_1745_n20# a_1910_n20# 0.00fF
C242 a_2625_n20# a_2130_n20# 0.00fF
C243 a_2570_n20# a_2240_n20# 0.00fF
C244 a_2515_n20# a_2295_n20# 0.00fF
C245 a_2680_n20# a_2075_n20# 0.00fF
C246 a_810_n20# VDD_1V8 1.46fF
C247 a_1470_n20# a_1800_n20# 0.00fF
C248 a_425_n20# a_700_n20# 0.00fF
C249 a_1030_n20# a_480_n20# 0.00fF
C250 w_n400_n400# a_205_n20# 0.07fF
C251 a_1525_n20# a_1415_n20# 0.01fF
C252 VDD_CORE a_2130_n20# 1.46fF
C253 a_1525_n20# a_1030_n20# 0.00fF
C254 VDD_1V8 a_880_0# 0.42fF
C255 a_1470_n20# a_1635_n20# 0.00fF
C256 a_2240_n20# a_2185_n20# 0.02fF
C257 a_2295_n20# a_2130_n20# 0.00fF
C258 a_1360_n20# a_1800_n20# 0.00fF
C259 a_3450_n20# a_3340_n20# 0.01fF
C260 a_40_n20# a_370_n20# 0.00fF
C261 a_1360_n20# a_1635_n20# 0.00fF
C262 a_2020_n20# a_1800_n20# 0.00fF
C263 a_315_n20# VDD_CORE 1.46fF
C264 a_1745_n20# a_2350_n20# 0.00fF
C265 a_2020_n20# a_1635_n20# 0.00fF
C266 a_2955_n20# a_2350_n20# 0.00fF
C267 VDD_CORE a_495_0# 0.42fF
C268 a_370_n20# VDD_1V8 1.46fF
C269 a_3450_n20# a_2955_n20# 0.00fF
C270 a_2185_n20# a_1580_n20# 0.00fF
C271 a_3285_n20# a_3120_n20# 0.00fF
C272 a_590_n20# a_95_n20# 0.00fF
C273 a_315_n20# a_535_n20# 0.00fF
C274 VDD_1V8 a_3065_n20# 1.46fF
C275 a_3395_n20# a_3120_n20# 0.00fF
C276 a_3175_n20# a_2790_n20# 0.00fF
C277 a_3230_n20# a_2735_n20# 0.00fF
C278 a_1690_n20# a_1910_n20# 0.00fF
C279 a_3285_n20# a_2680_n20# 0.00fF
C280 a_3120_n20# a_2900_n20# 0.00fF
C281 a_315_n20# a_810_n20# 0.00fF
C282 a_3010_n20# a_2405_n20# 0.00fF
C283 VDD_CORE a_3340_n20# 1.46fF
C284 a_755_n20# a_1085_n20# 0.00fF
C285 a_2845_n20# a_2460_n20# 0.00fF
C286 a_3065_n20# a_2515_n20# 0.00fF
C287 a_2955_n20# a_2625_n20# 0.00fF
C288 w_n400_n400# a_1195_n20# 0.07fF
C289 a_3010_n20# a_2570_n20# 0.00fF
C290 a_2900_n20# a_2680_n20# 0.00fF
C291 VDD_1V8 a_2075_n20# 1.46fF
C292 a_40_n20# a_645_n20# 0.00fF
C293 a_1305_n20# a_1800_n20# 0.00fF
C294 a_755_n20# a_975_n20# 0.00fF
C295 a_1745_n20# VDD_CORE 1.46fF
C296 VDD_CORE a_2955_n20# 1.46fF
C297 VDD_1V8 a_2310_0# 0.42fF
C298 a_1525_n20# a_1965_n20# 0.00fF
C299 a_1745_n20# a_2295_n20# 0.00fF
C300 a_1305_n20# a_1635_n20# 0.00fF
C301 a_1085_n20# a_480_n20# 0.00fF
C302 a_2020_n20# a_2405_n20# 0.00fF
C303 VDD_1V8 a_645_n20# 1.46fF
C304 a_1085_n20# a_1525_n20# 0.00fF
C305 a_1140_n20# VDD_CORE 1.46fF
C306 a_315_n20# a_370_n20# 0.02fF
C307 a_975_n20# a_480_n20# 0.00fF
C308 a_2570_n20# a_2020_n20# 0.00fF
C309 a_2515_n20# a_2075_n20# 0.00fF
C310 a_1415_n20# VDD_1V8 1.46fF
C311 a_1525_n20# a_975_n20# 0.00fF
C312 a_920_n20# a_1195_n20# 0.00fF
C313 VDD_1V8 a_1030_n20# 1.46fF
C314 a_1140_n20# a_535_n20# 0.00fF
C315 a_2130_n20# a_2075_n20# 0.02fF
C316 a_2185_n20# a_2020_n20# 0.00fF
C317 a_755_n20# a_260_n20# 0.00fF
C318 a_150_n20# a_205_n20# 0.02fF
C319 a_1140_n20# a_810_n20# 0.00fF
C320 w_n400_n400# a_2790_n20# 0.07fF
C321 a_3450_n20# a_3230_n20# 0.00fF
C322 VDD_CORE a_700_n20# 1.46fF
C323 a_1250_n20# a_1195_n20# 0.02fF
C324 VDD_1V8 a_3285_n20# 1.46fF
C325 a_2735_n20# a_2350_n20# 0.00fF
C326 VDD_1V8 a_3395_n20# 1.46fF
C327 a_1690_n20# VDD_CORE 1.46fF
C328 a_260_n20# a_480_n20# 0.00fF
C329 a_3175_n20# a_3120_n20# 0.02fF
C330 a_3340_n20# a_3065_n20# 0.00fF
C331 a_535_n20# a_700_n20# 0.00fF
C332 a_1690_n20# a_2295_n20# 0.00fF
C333 VDD_CORE a_605_0# 0.42fF
C334 a_315_n20# a_645_n20# 0.00fF
C335 VDD_1V8 a_2900_n20# 1.46fF
C336 a_3065_n20# a_2955_n20# 0.01fF
C337 a_3175_n20# a_2680_n20# 0.00fF
C338 a_3230_n20# a_2625_n20# 0.00fF
C339 a_810_n20# a_700_n20# 0.01fF
C340 a_1580_n20# a_1195_n20# 0.00fF
C341 a_2845_n20# a_2405_n20# 0.00fF
C342 a_1910_n20# a_2350_n20# 0.00fF
C343 VDD_CORE a_3230_n20# 1.46fF
C344 a_425_n20# VDD_CORE 1.46fF
C345 a_2735_n20# a_2625_n20# 0.01fF
C346 a_590_n20# a_205_n20# 0.00fF
C347 a_2900_n20# a_2515_n20# 0.00fF
C348 a_2845_n20# a_2570_n20# 0.00fF
C349 VDD_1V8 a_1965_n20# 1.46fF
C350 VDD_CORE a_2735_n20# 1.46fF
C351 a_425_n20# a_535_n20# 0.01fF
C352 a_1085_n20# VDD_1V8 1.46fF
C353 a_1525_n20# a_1855_n20# 0.00fF
C354 a_1745_n20# a_2075_n20# 0.00fF
C355 a_755_n20# w_n400_n400# 0.07fF
C356 a_2790_n20# a_2240_n20# 0.00fF
C357 a_2735_n20# a_2295_n20# 0.00fF
C358 VDD_1V8 a_975_n20# 1.46fF
C359 VDD_CORE a_2035_0# 0.42fF
C360 a_370_n20# a_700_n20# 0.00fF
C361 a_810_n20# a_425_n20# 0.00fF
C362 a_2515_n20# a_1965_n20# 0.00fF
C363 w_n400_n400# a_480_n20# 0.07fF
C364 a_1470_n20# a_1195_n20# 0.00fF
C365 a_1525_n20# w_n400_n400# 0.07fF
C366 VDD_CORE a_1910_n20# 1.46fF
C367 a_1415_n20# a_1745_n20# 0.00fF
C368 w_n400_n400# a_3120_n20# 0.07fF
C369 VDD_1V8 a_550_0# 0.42fF
C370 a_1140_n20# a_645_n20# 0.00fF
C371 VDD_1V8 m5_0_3175# 4.14fF
C372 a_2130_n20# a_1965_n20# 0.00fF
C373 a_2295_n20# a_1910_n20# 0.00fF
C374 a_755_n20# a_920_n20# 0.00fF
C375 a_1360_n20# a_1195_n20# 0.00fF
C376 a_1140_n20# a_1415_n20# 0.00fF
C377 a_1140_n20# a_1030_n20# 0.01fF
C378 a_260_n20# a_40_n20# 0.00fF
C379 w_n400_n400# a_2680_n20# 0.07fF
C380 a_3340_n20# a_3285_n20# 0.02fF
C381 a_590_n20# a_1195_n20# 0.00fF
C382 VDD_1V8 a_3175_n20# 1.46fF
C383 a_3395_n20# a_3340_n20# 0.02fF
C384 a_425_n20# a_370_n20# 0.02fF
C385 a_2625_n20# a_2350_n20# 0.00fF
C386 a_920_n20# a_480_n20# 0.00fF
C387 a_1800_n20# a_1635_n20# 0.00fF
C388 a_260_n20# VDD_1V8 1.46fF
C389 a_1525_n20# a_920_n20# 0.00fF
C390 a_1690_n20# a_2075_n20# 0.00fF
C391 a_3340_n20# a_2900_n20# 0.00fF
C392 a_3285_n20# a_2955_n20# 0.00fF
C393 a_3230_n20# a_3065_n20# 0.00fF
C394 a_1250_n20# a_755_n20# 0.00fF
C395 a_700_n20# a_645_n20# 0.02fF
C396 VDD_CORE a_2350_n20# 1.46fF
C397 VDD_CORE a_3450_n20# 1.46fF
C398 a_3395_n20# a_2955_n20# 0.00fF
C399 a_2295_n20# a_2350_n20# 0.02fF
C400 VDD_1V8 a_2860_0# 0.42fF
C401 a_2955_n20# a_2900_n20# 0.02fF
C402 a_3065_n20# a_2735_n20# 0.00fF
C403 a_3010_n20# a_2790_n20# 0.00fF
C404 a_1030_n20# a_700_n20# 0.00fF
C405 a_2405_n20# a_2460_n20# 0.02fF
C406 a_2570_n20# a_2460_n20# 0.01fF
C407 a_1690_n20# a_1415_n20# 0.00fF
C408 a_1250_n20# a_1525_n20# 0.00fF
C409 VDD_1V8 a_1855_n20# 1.46fF
C410 a_1305_n20# a_1195_n20# 0.01fF
C411 VDD_CORE a_2625_n20# 1.46fF
C412 a_2185_n20# a_2460_n20# 0.00fF
C413 VDD_1V8 a_1430_0# 0.42fF
C414 a_1745_n20# a_1965_n20# 0.00fF
C415 a_2625_n20# a_2295_n20# 0.00fF
C416 a_2680_n20# a_2240_n20# 0.00fF
C417 a_425_n20# a_645_n20# 0.00fF
C418 a_40_n20# w_n400_n400# 0.07fF
C419 a_1800_n20# a_2405_n20# 0.00fF
C420 VDD_CORE a_2295_n20# 1.46fF
C421 a_260_n20# a_315_n20# 0.02fF
C422 VDD_1V8 a_2970_0# 0.42fF
C423 a_755_n20# a_150_n20# 0.00fF
C424 a_425_n20# a_1030_n20# 0.00fF
C425 a_1525_n20# a_1580_n20# 0.02fF
C426 w_n400_n400# VDD_1V8 106.09fF
C427 a_1140_n20# a_1085_n20# 0.02fF
C428 a_535_n20# VDD_CORE 1.46fF
C429 a_2130_n20# a_1855_n20# 0.00fF
C430 a_2075_n20# a_1910_n20# 0.00fF
C431 a_2185_n20# a_1800_n20# 0.00fF
C432 a_865_n20# a_1195_n20# 0.00fF
C433 VDD_CORE a_1705_0# 0.42fF
C434 a_1140_n20# a_975_n20# 0.00fF
C435 a_150_n20# a_480_n20# 0.00fF
C436 a_810_n20# VDD_CORE 1.46fF
C437 a_2185_n20# a_1635_n20# 0.00fF
C438 a_3450_n20# a_3065_n20# 0.00fF
C439 w_n400_n400# a_2515_n20# 0.07fF
C440 a_3340_n20# a_3175_n20# 0.00fF
C441 a_3285_n20# a_3230_n20# 0.02fF
C442 a_920_n20# VDD_1V8 1.46fF
C443 a_3395_n20# a_3230_n20# 0.00fF
C444 a_755_n20# a_1360_n20# 0.00fF
C445 a_3505_n20# a_3120_n20# 0.00fF
C446 a_810_n20# a_535_n20# 0.00fF
C447 w_n400_n400# a_2130_n20# 0.07fF
C448 a_1415_n20# a_1910_n20# 0.00fF
C449 a_1085_n20# a_700_n20# 0.00fF
C450 a_1690_n20# a_1965_n20# 0.00fF
C451 a_3120_n20# a_3010_n20# 0.01fF
C452 a_3230_n20# a_2900_n20# 0.00fF
C453 a_3285_n20# a_2735_n20# 0.00fF
C454 a_3175_n20# a_2955_n20# 0.00fF
C455 a_755_n20# a_590_n20# 0.00fF
C456 a_1525_n20# a_1470_n20# 0.02fF
C457 a_975_n20# a_700_n20# 0.00fF
C458 a_2075_n20# a_2350_n20# 0.00fF
C459 a_1085_n20# a_1690_n20# 0.00fF
C460 a_2900_n20# a_2735_n20# 0.00fF
C461 VDD_CORE a_3465_0# 0.42fF
C462 a_3010_n20# a_2680_n20# 0.00fF
C463 a_3065_n20# a_2625_n20# 0.00fF
C464 a_2845_n20# a_2790_n20# 0.02fF
C465 a_370_n20# VDD_CORE 1.46fF
C466 a_1525_n20# a_1360_n20# 0.00fF
C467 a_2570_n20# a_2405_n20# 0.00fF
C468 a_1250_n20# VDD_1V8 1.46fF
C469 a_315_n20# w_n400_n400# 0.07fF
C470 VDD_1V8 a_2240_n20# 1.46fF
C471 VDD_CORE a_3065_n20# 1.46fF
C472 a_590_n20# a_480_n20# 0.01fF
C473 a_1525_n20# a_2020_n20# 0.00fF
C474 a_2185_n20# a_2405_n20# 0.00fF
C475 a_535_n20# a_370_n20# 0.00fF
C476 VDD_1V8 a_3080_0# 0.42fF
C477 VDD_1V8 a_1320_0# 0.42fF
C478 a_1745_n20# a_1855_n20# 0.01fF
C479 a_2625_n20# a_2075_n20# 0.00fF
C480 a_2515_n20# a_2240_n20# 0.00fF
C481 a_95_n20# a_205_n20# 0.01fF
C482 a_2570_n20# a_2185_n20# 0.00fF
C483 a_810_n20# a_370_n20# 0.00fF
C484 VDD_1V8 a_1580_n20# 1.46fF
C485 a_425_n20# a_975_n20# 0.00fF
C486 a_920_n20# a_315_n20# 0.00fF
C487 a_260_n20# a_700_n20# 0.00fF
C488 a_755_n20# a_1305_n20# 0.00fF
C489 VDD_CORE a_2075_n20# 1.46fF
C490 w_n400_n400# a_3340_n20# 0.07fF
C491 a_2295_n20# a_2075_n20# 0.00fF
C492 a_2240_n20# a_2130_n20# 0.01fF
C493 a_40_n20# a_150_n20# 0.01fF
C494 VDD_CORE a_645_n20# 1.46fF
C495 w_n400_n400# a_1745_n20# 0.07fF
C496 a_3450_n20# a_3285_n20# 0.00fF
C497 w_n400_n400# a_2955_n20# 0.07fF
C498 a_150_n20# VDD_1V8 1.46fF
C499 a_1965_n20# a_1910_n20# 0.02fF
C500 a_3395_n20# a_3450_n20# 0.02fF
C501 a_1525_n20# a_1305_n20# 0.00fF
C502 VDD_CORE m5_0_n220# 4.14fF
C503 a_1415_n20# VDD_CORE 1.46fF
C504 VDD_CORE a_1030_n20# 1.46fF
C505 a_2900_n20# a_2350_n20# 0.00fF
C506 a_1140_n20# w_n400_n400# 0.07fF
C507 a_535_n20# a_645_n20# 0.01fF
C508 VDD_1V8 a_3505_n20# 1.46fF
C509 a_3450_n20# a_2900_n20# 0.00fF
C510 a_2130_n20# a_1580_n20# 0.00fF
C511 a_3230_n20# a_3175_n20# 0.02fF
C512 a_755_n20# a_865_n20# 0.01fF
C513 VDD_CORE a_715_0# 0.42fF
C514 a_1800_n20# a_1195_n20# 0.00fF
C515 a_260_n20# a_425_n20# 0.00fF
C516 VDD_1V8 a_3010_n20# 1.46fF
C517 a_535_n20# a_1030_n20# 0.00fF
C518 a_810_n20# a_645_n20# 0.00fF
C519 a_1470_n20# VDD_1V8 1.46fF
C520 a_1635_n20# a_1195_n20# 0.00fF
C521 a_1690_n20# a_1855_n20# 0.00fF
C522 a_3120_n20# a_2845_n20# 0.00fF
C523 a_3175_n20# a_2735_n20# 0.00fF
C524 VDD_CORE a_2365_0# 0.42fF
C525 a_865_n20# a_480_n20# 0.00fF
C526 a_590_n20# a_40_n20# 0.00fF
C527 a_1360_n20# VDD_1V8 1.46fF
C528 a_810_n20# a_1415_n20# 0.00fF
C529 a_1965_n20# a_2350_n20# 0.00fF
C530 a_810_n20# a_1030_n20# 0.00fF
C531 VDD_CORE a_3285_n20# 1.46fF
C532 a_1140_n20# a_920_n20# 0.00fF
C533 a_2790_n20# a_2460_n20# 0.00fF
C534 a_3010_n20# a_2515_n20# 0.00fF
C535 a_2900_n20# a_2625_n20# 0.00fF
C536 a_2845_n20# a_2680_n20# 0.00fF
C537 w_n400_n400# a_700_n20# 0.07fF
C538 VDD_CORE a_3395_n20# 1.46fF
C539 VDD_1V8 a_2020_n20# 1.46fF
C540 a_590_n20# VDD_1V8 1.46fF
C541 VDD_CORE a_2900_n20# 1.46fF
C542 a_1690_n20# w_n400_n400# 0.07fF
C543 a_1250_n20# a_1745_n20# 0.00fF
C544 a_1745_n20# a_2240_n20# 0.00fF
C545 a_2900_n20# a_2295_n20# 0.00fF
C546 a_315_n20# a_150_n20# 0.00fF
C547 a_370_n20# a_645_n20# 0.00fF
C548 a_1250_n20# a_1140_n20# 0.01fF
C549 a_2515_n20# a_2020_n20# 0.00fF
C550 a_920_n20# a_700_n20# 0.00fF
C551 VDD_CORE a_1965_n20# 1.46fF
C552 w_n400_n400# a_3230_n20# 0.07fF
C553 a_425_n20# w_n400_n400# 0.07fF
C554 VDD_1V8 a_660_0# 0.42fF
C555 a_1745_n20# a_1580_n20# 0.00fF
C556 a_2130_n20# a_2020_n20# 0.01fF
C557 a_2295_n20# a_1965_n20# 0.00fF
C558 a_1085_n20# VDD_CORE 1.46fF
C559 a_1305_n20# VDD_1V8 1.46fF
C560 VDD_CORE a_1595_0# 0.42fF
C561 a_3450_n20# a_3175_n20# 0.00fF
C562 VDD_1V8 a_330_0# 0.42fF
C563 a_1140_n20# a_1580_n20# 0.00fF
C564 w_n400_n400# a_2735_n20# 0.07fF
C565 VDD_CORE a_975_n20# 1.46fF
C566 a_1910_n20# a_1855_n20# 0.02fF
C567 a_1250_n20# a_700_n20# 0.00fF
C568 a_1085_n20# a_535_n20# 0.00fF
C569 a_3505_n20# a_3340_n20# 0.00fF
C570 a_590_n20# a_315_n20# 0.00fF
C571 VDD_CORE a_1485_0# 0.42fF
C572 a_1250_n20# a_1690_n20# 0.00fF
C573 a_920_n20# a_425_n20# 0.00fF
C574 a_1690_n20# a_2240_n20# 0.00fF
C575 a_3285_n20# a_3065_n20# 0.00fF
C576 a_535_n20# a_975_n20# 0.00fF
C577 a_3340_n20# a_3010_n20# 0.00fF
C578 a_1085_n20# a_810_n20# 0.00fF
C579 VDD_1V8 a_2845_n20# 1.46fF
C580 a_3395_n20# a_3065_n20# 0.00fF
C581 a_3505_n20# a_2955_n20# 0.00fF
C582 w_n400_n400# a_1910_n20# 0.07fF
C583 a_1030_n20# a_645_n20# 0.00fF
C584 a_3010_n20# a_2955_n20# 0.02fF
C585 a_3065_n20# a_2900_n20# 0.00fF
C586 a_810_n20# a_975_n20# 0.00fF
C587 a_3175_n20# a_2625_n20# 0.00fF
C588 a_865_n20# VDD_1V8 1.46fF
C589 VDD_CORE a_165_0# 0.42fF
C590 a_1470_n20# a_1745_n20# 0.00fF
C591 a_2790_n20# a_2405_n20# 0.00fF
C592 VDD_1V8 a_2200_0# 0.42fF
C593 a_1855_n20# a_2350_n20# 0.00fF
C594 a_1415_n20# a_1030_n20# 0.00fF
C595 VDD_CORE a_3175_n20# 1.46fF
C596 a_2680_n20# a_2460_n20# 0.00fF
C597 a_260_n20# VDD_CORE 1.46fF
C598 a_2845_n20# a_2515_n20# 0.00fF
C599 a_2790_n20# a_2570_n20# 0.00fF
C600 a_1690_n20# a_1580_n20# 0.01fF
C601 a_3520_0# VDD_1V8 0.42fF
C602 a_1745_n20# a_1360_n20# 0.00fF
C603 a_1140_n20# a_1470_n20# 0.00fF
C604 VDD_CORE a_2255_0# 0.42fF
C605 a_1525_n20# a_1800_n20# 0.00fF
C606 a_150_n20# a_700_n20# 0.00fF
C607 a_1745_n20# a_2020_n20# 0.00fF
C608 a_2790_n20# a_2185_n20# 0.00fF
C609 a_260_n20# a_535_n20# 0.00fF
C610 a_2735_n20# a_2240_n20# 0.00fF
C611 a_1140_n20# a_1360_n20# 0.00fF
C612 w_n400_n400# a_2350_n20# 0.07fF
C613 VDD_CORE a_3245_0# 0.42fF
C614 w_n400_n400# a_3450_n20# 0.07fF
C615 a_1525_n20# a_1635_n20# 0.01fF
C616 a_370_n20# a_975_n20# 0.00fF
C617 a_95_n20# a_480_n20# 0.00fF
C618 a_1140_n20# a_590_n20# 0.00fF
C619 a_260_n20# a_810_n20# 0.00fF
C620 VDD_CORE a_1855_n20# 1.46fF
C621 VDD_1V8 a_1980_0# 0.42fF
C622 a_2295_n20# a_1855_n20# 0.00fF
C623 a_2240_n20# a_1910_n20# 0.00fF
C624 a_2075_n20# a_1965_n20# 0.01fF
C625 a_865_n20# a_315_n20# 0.00fF
C626 a_1690_n20# a_1470_n20# 0.00fF
C627 a_425_n20# a_150_n20# 0.00fF
C628 VDD_1V8 a_110_0# 0.42fF
C629 w_n400_n400# a_2625_n20# 0.07fF
C630 VDD_CORE a_1045_0# 0.42fF
C631 a_1690_n20# a_1360_n20# 0.00fF
C632 a_1305_n20# a_1745_n20# 0.00fF
C633 a_1085_n20# a_645_n20# 0.00fF
C634 a_3505_n20# a_3230_n20# 0.00fF
C635 a_3395_n20# a_3285_n20# 0.01fF
C636 a_590_n20# a_700_n20# 0.01fF
C637 w_n400_n400# VDD_CORE 85.21fF
C638 a_260_n20# a_370_n20# 0.01fF
C639 w_n400_n400# a_2295_n20# 0.07fF
C640 a_1415_n20# a_1965_n20# 0.00fF
C641 a_1690_n20# a_2020_n20# 0.00fF
C642 a_1910_n20# a_1580_n20# 0.00fF
C643 a_3175_n20# a_3065_n20# 0.01fF
C644 a_3285_n20# a_2900_n20# 0.00fF
C645 a_3230_n20# a_3010_n20# 0.00fF
C646 a_3340_n20# a_2845_n20# 0.00fF
C647 a_975_n20# a_645_n20# 0.00fF
C648 VDD_1V8 a_2460_n20# 1.46fF
C649 a_1140_n20# a_1305_n20# 0.00fF
C650 a_1085_n20# a_1415_n20# 0.00fF
C651 a_1085_n20# a_1030_n20# 0.02fF
C652 a_3395_n20# a_2900_n20# 0.00fF
C653 a_2240_n20# a_2350_n20# 0.01fF
C654 a_535_n20# w_n400_n400# 0.07fF
C655 a_3010_n20# a_2735_n20# 0.00fF
C656 a_2955_n20# a_2845_n20# 0.01fF
C657 a_1415_n20# a_975_n20# 0.00fF
C658 a_3120_n20# a_2570_n20# 0.00fF
C659 a_975_n20# a_1030_n20# 0.02fF
C660 a_2680_n20# a_2405_n20# 0.00fF
C661 a_810_n20# w_n400_n400# 0.07fF
C662 a_920_n20# VDD_CORE 1.46fF
C663 a_2515_n20# a_2460_n20# 0.02fF
C664 VDD_CORE a_2145_0# 0.42fF
C665 a_2680_n20# a_2570_n20# 0.01fF
C666 a_590_n20# a_425_n20# 0.00fF
C667 VDD_1V8 a_1800_n20# 1.46fF
C668 a_40_n20# a_95_n20# 0.02fF
C669 a_1305_n20# a_700_n20# 0.00fF
C670 a_1140_n20# a_865_n20# 0.00fF
C671 a_920_n20# a_535_n20# 0.00fF
C672 a_2130_n20# a_2460_n20# 0.00fF
C673 VDD_1V8 a_1635_n20# 1.46fF
C674 a_2625_n20# a_2240_n20# 0.00fF
C675 a_2680_n20# a_2185_n20# 0.00fF
C676 a_260_n20# a_645_n20# 0.00fF
C677 a_1690_n20# a_1305_n20# 0.00fF
C678 a_1470_n20# a_1910_n20# 0.00fF
C679 a_95_n20# VDD_1V8 1.46fF
C680 VDD_1V8 a_2640_0# 0.42fF
C681 a_1250_n20# VDD_CORE 1.46fF
C682 VDD_CORE a_2240_n20# 1.46fF
C683 a_920_n20# a_810_n20# 0.01fF
C684 VDD_1V8 a_990_0# 0.42fF
C685 a_2295_n20# a_2240_n20# 0.02fF
C686 a_1360_n20# a_1910_n20# 0.00fF
C687 a_755_n20# a_205_n20# 0.00fF
C688 w_n400_n400# a_370_n20# 0.07fF
C689 w_n400_n400# a_3065_n20# 0.07fF
C690 a_2075_n20# a_1855_n20# 0.00fF
C691 a_2020_n20# a_1910_n20# 0.01fF
C692 a_2130_n20# a_1800_n20# 0.00fF
C693 a_3505_n20# a_3450_n20# 0.02fF
C694 a_865_n20# a_700_n20# 0.00fF
C695 a_480_n20# a_205_n20# 0.00fF
C696 a_2130_n20# a_1635_n20# 0.00fF
C697 VDD_CORE a_1580_n20# 1.46fF
C698 a_3450_n20# a_3010_n20# 0.00fF
C699 a_1250_n20# a_810_n20# 0.00fF
C700 VDD_1V8 a_0_0# 0.42fF
C701 a_3285_n20# a_3175_n20# 0.01fF
C702 VDD_CORE a_825_0# 0.42fF
C703 a_920_n20# a_370_n20# 0.00fF
C704 a_3395_n20# a_3175_n20# 0.00fF
C705 VDD_1V8 a_2405_n20# 1.46fF
C706 a_1085_n20# a_975_n20# 0.01fF
C707 a_1415_n20# a_1855_n20# 0.00fF
C708 w_n400_n400# a_2075_n20# 0.07fF
C709 a_3175_n20# a_2900_n20# 0.00fF
C710 a_3230_n20# a_2845_n20# 0.00fF
C711 a_150_n20# VDD_CORE 1.46fF
C712 VDD_1V8 a_2570_n20# 1.46fF
C713 a_315_n20# a_95_n20# 0.00fF
C714 a_2020_n20# a_2350_n20# 0.00fF
C715 w_n400_n400# a_645_n20# 0.07fF
C716 VDD_CORE a_2585_0# 0.42fF
C717 a_865_n20# a_425_n20# 0.00fF
C718 a_2955_n20# a_2460_n20# 0.00fF
C719 a_2845_n20# a_2735_n20# 0.01fF
C720 a_3010_n20# a_2625_n20# 0.00fF
C721 VDD_CORE a_3505_n20# 1.46fF
C722 VDD_CORE a_3135_0# 0.42fF
C723 a_2515_n20# a_2405_n20# 0.01fF
C724 VDD_1V8 a_2185_n20# 1.46fF
C725 a_1305_n20# a_1910_n20# 0.00fF
C726 a_150_n20# a_535_n20# 0.00fF
C727 w_n400_n400# m5_0_n220# 2.90fF
C728 w_n400_n400# a_1415_n20# 0.07fF
C729 a_755_n20# a_1195_n20# 0.00fF
C730 w_n400_n400# a_1030_n20# 0.07fF
C731 VDD_CORE a_3010_n20# 1.46fF
C732 a_2570_n20# a_2515_n20# 0.02fF
C733 a_1470_n20# VDD_CORE 1.46fF
C734 a_2130_n20# a_2405_n20# 0.00fF
C735 a_920_n20# a_645_n20# 0.00fF
C736 a_2570_n20# a_2130_n20# 0.00fF
C737 a_2515_n20# a_2185_n20# 0.00fF
C738 a_1745_n20# a_1800_n20# 0.02fF
C739 a_2625_n20# a_2020_n20# 0.00fF
C740 a_1360_n20# VDD_CORE 1.46fF
C741 a_1525_n20# a_1195_n20# 0.00fF
C742 a_1745_n20# a_1635_n20# 0.01fF
C743 VDD_CORE a_2020_n20# 1.46fF
C744 a_920_n20# a_1415_n20# 0.00fF
C745 w_n400_n400# a_3285_n20# 0.07fF
C746 a_590_n20# VDD_CORE 1.46fF
C747 a_920_n20# a_1030_n20# 0.01fF
C748 a_2240_n20# a_2075_n20# 0.00fF
C749 a_2295_n20# a_2020_n20# 0.00fF
C750 a_2185_n20# a_2130_n20# 0.02fF
C751 w_n400_n400# a_3395_n20# 0.07fF
C752 a_40_n20# a_205_n20# 0.00fF
C753 a_1140_n20# a_1635_n20# 0.00fF
C754 a_1250_n20# a_645_n20# 0.00fF
C755 w_n400_n400# a_2900_n20# 0.07fF
C756 a_590_n20# a_535_n20# 0.02fF
C757 a_1965_n20# a_1855_n20# 0.01fF
C758 VDD_1V8 a_1760_0# 0.42fF
C759 a_810_n20# a_1360_n20# 0.00fF
C760 a_150_n20# a_370_n20# 0.00fF
C761 VDD_1V8 a_205_n20# 1.46fF
C762 VDD_1V8 a_770_0# 0.42fF
C763 a_2845_n20# a_2350_n20# 0.00fF
C764 a_3450_n20# a_2845_n20# 0.00fF
C765 a_1250_n20# a_1415_n20# 0.00fF
C766 a_1250_n20# a_1030_n20# 0.00fF
C767 a_590_n20# a_810_n20# 0.00fF
C768 a_2075_n20# a_1580_n20# 0.00fF
C769 a_3505_n20# a_3065_n20# 0.00fF
C770 w_n400_n400# a_1965_n20# 0.07fF
C771 a_3065_n20# a_3010_n20# 0.02fF
C772 a_3120_n20# a_2790_n20# 0.00fF
C773 a_1690_n20# a_1800_n20# 0.01fF
C774 a_1305_n20# VDD_CORE 1.46fF
C775 a_2955_n20# a_2405_n20# 0.00fF
C776 a_1085_n20# w_n400_n400# 0.07fF
C777 a_95_n20# a_700_n20# 0.00fF
C778 a_1690_n20# a_1635_n20# 0.02fF
C779 a_1415_n20# a_1580_n20# 0.00fF
C780 a_1030_n20# a_1580_n20# 0.00fF
C781 a_2735_n20# a_2460_n20# 0.00fF
C782 a_2790_n20# a_2680_n20# 0.01fF
C783 a_2955_n20# a_2570_n20# 0.00fF
C784 a_2845_n20# a_2625_n20# 0.00fF
C785 w_n400_n400# a_975_n20# 0.07fF
C786 VDD_CORE a_1815_0# 0.42fF
C787 a_590_n20# a_370_n20# 0.00fF
C788 a_150_n20# a_645_n20# 0.00fF
C789 VDD_CORE a_2845_n20# 1.46fF
C790 a_1745_n20# a_2185_n20# 0.00fF
C791 a_2845_n20# a_2295_n20# 0.00fF
C792 a_3300_0# VDD_1V8 0.42fF
C793 a_1305_n20# a_810_n20# 0.00fF
C794 a_315_n20# a_205_n20# 0.01fF
C795 w_n400_n400# m5_0_3175# 2.90fF
C796 a_1470_n20# a_2075_n20# 0.00fF
C797 a_1085_n20# a_920_n20# 0.00fF
C798 a_865_n20# VDD_CORE 1.46fF
C799 VDD_1V8 a_1195_n20# 1.46fF
C800 a_1910_n20# a_2460_n20# 0.00fF
C801 a_425_n20# a_95_n20# 0.00fF
C802 a_920_n20# a_975_n20# 0.02fF
C803 a_865_n20# a_535_n20# 0.00fF
C804 w_n400_n400# a_3175_n20# 0.07fF
C805 a_2075_n20# a_2020_n20# 0.02fF
C806 a_2240_n20# a_1965_n20# 0.00fF
C807 a_755_n20# a_480_n20# 0.00fF
C808 VDD_CORE VGATE 3.02fF
C809 a_260_n20# w_n400_n400# 0.07fF
C810 a_1470_n20# a_1415_n20# 0.02fF
C811 a_1470_n20# a_1030_n20# 0.00fF
C812 a_1250_n20# a_1085_n20# 0.00fF
C813 a_865_n20# a_810_n20# 0.02fF
C814 a_1910_n20# a_1800_n20# 0.01fF
C815 a_1415_n20# a_1360_n20# 0.02fF
C816 a_590_n20# a_645_n20# 0.02fF
C817 a_1360_n20# a_1030_n20# 0.00fF
C818 VDD_CORE a_1155_0# 0.42fF
C819 a_1250_n20# a_975_n20# 0.00fF
C820 a_2460_n20# a_2350_n20# 0.01fF
C821 a_3505_n20# a_3285_n20# 0.00fF
C822 a_1910_n20# a_1635_n20# 0.00fF
C823 a_1415_n20# a_2020_n20# 0.00fF
C824 a_3505_n20# a_3395_n20# 0.01fF
C825 a_3285_n20# a_3010_n20# 0.00fF
C826 a_1965_n20# a_1580_n20# 0.00fF
C827 a_590_n20# a_1030_n20# 0.00fF
C828 a_1690_n20# a_2185_n20# 0.00fF
C829 VDD_1V8 a_2790_n20# 1.46fF
C830 a_3505_n20# a_2900_n20# 0.00fF
C831 a_3395_n20# a_3010_n20# 0.00fF
C832 a_1085_n20# a_1580_n20# 0.00fF
C833 w_n400_n400# a_1855_n20# 0.07fF
C834 a_3065_n20# a_2845_n20# 0.00fF
C835 a_3120_n20# a_2680_n20# 0.00fF
C836 VDD_1V8 a_2420_0# 0.42fF
C837 a_3010_n20# a_2900_n20# 0.01fF
C838 a_975_n20# a_1580_n20# 0.00fF
C839 a_865_n20# a_370_n20# 0.00fF
C840 a_2735_n20# a_2405_n20# 0.00fF
C841 a_1800_n20# a_2350_n20# 0.00fF
C842 a_2625_n20# a_2460_n20# 0.00fF
C843 a_2790_n20# a_2515_n20# 0.00fF
C844 a_2735_n20# a_2570_n20# 0.00fF
C845 VDD_CORE a_2460_n20# 1.46fF
C846 a_2295_n20# a_2460_n20# 0.00fF
C847 a_2735_n20# a_2185_n20# 0.00fF
C848 a_1305_n20# a_1415_n20# 0.01fF
C849 a_700_n20# a_205_n20# 0.00fF
C850 a_1910_n20# a_2405_n20# 0.00fF
C851 a_1305_n20# a_1030_n20# 0.00fF
C852 a_1470_n20# a_1965_n20# 0.00fF
C853 VDD_1V8 a_1100_0# 0.42fF
C854 a_1085_n20# a_1470_n20# 0.00fF
C855 a_1745_n20# a_1195_n20# 0.00fF
C856 a_1360_n20# a_1965_n20# 0.00fF
C857 a_755_n20# VDD_1V8 1.46fF
C858 VDD_CORE a_1800_n20# 1.46fF
C859 a_1470_n20# a_975_n20# 0.00fF
C860 a_1085_n20# a_1360_n20# 0.00fF
C861 a_920_n20# w_n400_n400# 0.07fF
C862 a_865_n20# a_645_n20# 0.00fF
C863 a_2185_n20# a_1910_n20# 0.00fF
C864 a_2240_n20# a_1855_n20# 0.00fF
C865 a_1250_n20# a_1855_n20# 0.00fF
C866 a_2020_n20# a_1965_n20# 0.02fF
C867 a_2295_n20# a_1800_n20# 0.00fF
C868 a_40_n20# a_480_n20# 0.00fF
C869 a_1140_n20# a_1195_n20# 0.02fF
C870 VDD_CORE a_1375_0# 0.42fF
C871 VDD_CORE a_1635_n20# 1.46fF
C872 a_1360_n20# a_975_n20# 0.00fF
C873 a_865_n20# a_1415_n20# 0.00fF
C874 a_1085_n20# a_590_n20# 0.00fF
C875 a_865_n20# a_1030_n20# 0.00fF
C876 a_2405_n20# a_2350_n20# 0.02fF
C877 a_95_n20# VDD_CORE 1.46fF
C878 a_260_n20# a_150_n20# 0.01fF
C879 VDD_1V8 a_480_n20# 1.46fF
C880 a_425_n20# a_205_n20# 0.00fF
C881 a_590_n20# a_975_n20# 0.00fF
C882 a_1525_n20# VDD_1V8 1.46fF
C883 VDD_1V8 a_3120_n20# 1.46fF
C884 a_3505_n20# a_3175_n20# 0.00fF
C885 a_2570_n20# a_2350_n20# 0.00fF
C886 w_n400_n400# a_2240_n20# 0.07fF
C887 a_1250_n20# w_n400_n400# 0.07fF
C888 a_535_n20# a_95_n20# 0.00fF
C889 a_1855_n20# a_1580_n20# 0.00fF
C890 a_3285_n20# a_2845_n20# 0.00fF
C891 a_3175_n20# a_3010_n20# 0.00fF
C892 a_3340_n20# a_2790_n20# 0.00fF
C893 VGATE m5_0_n220# 2.25fF
C894 VDD_1V8 a_2090_0# 0.42fF
C895 VDD_1V8 a_2680_n20# 1.46fF
C896 a_3395_n20# a_2845_n20# 0.00fF
C897 a_2185_n20# a_2350_n20# 0.00fF
C898 a_700_n20# a_1195_n20# 0.00fF
C899 a_3065_n20# a_2460_n20# 0.00fF
C900 a_2955_n20# a_2790_n20# 0.00fF
C901 a_3120_n20# a_2515_n20# 0.00fF
C902 a_2900_n20# a_2845_n20# 0.02fF
C903 a_2625_n20# a_2405_n20# 0.00fF
C904 a_1690_n20# a_1195_n20# 0.00fF
C905 m5_0_n220# $SUB -1.44fF $ **FLOATING
C906 VDD_CORE $SUB -82.50fF $ **FLOATING
C907 VDD_1V8 $SUB -81.14fF $ **FLOATING
C908 w_n400_n400# $SUB 205.36fF
.end
