* Sky130 Extracted 5-Bit Resistor DAC with PEX Parasitics
.subckt dac_5bit_pex vref d4 d3 d2 d1 d0 vout vss agnd
* 32 Unit Resistors (500 Ohms) + Parasitic Interconnect (2.4 Ohms/tap, 15 fF/tap)
R0 tap_0 tap_1 500.0
R_int_0 tap_0 tap_0_int 2.4
C_sub_0 tap_0 agnd 15.0f
R1 tap_1 tap_2 500.0
R_int_1 tap_1 tap_1_int 2.4
C_sub_1 tap_1 agnd 15.0f
R2 tap_2 tap_3 500.0
R_int_2 tap_2 tap_2_int 2.4
C_sub_2 tap_2 agnd 15.0f
R3 tap_3 tap_4 500.0
R_int_3 tap_3 tap_3_int 2.4
C_sub_3 tap_3 agnd 15.0f
R4 tap_4 tap_5 500.0
R_int_4 tap_4 tap_4_int 2.4
C_sub_4 tap_4 agnd 15.0f
R5 tap_5 tap_6 500.0
R_int_5 tap_5 tap_5_int 2.4
C_sub_5 tap_5 agnd 15.0f
R6 tap_6 tap_7 500.0
R_int_6 tap_6 tap_6_int 2.4
C_sub_6 tap_6 agnd 15.0f
R7 tap_7 tap_8 500.0
R_int_7 tap_7 tap_7_int 2.4
C_sub_7 tap_7 agnd 15.0f
R8 tap_8 tap_9 500.0
R_int_8 tap_8 tap_8_int 2.4
C_sub_8 tap_8 agnd 15.0f
R9 tap_9 tap_10 500.0
R_int_9 tap_9 tap_9_int 2.4
C_sub_9 tap_9 agnd 15.0f
R10 tap_10 tap_11 500.0
R_int_10 tap_10 tap_10_int 2.4
C_sub_10 tap_10 agnd 15.0f
R11 tap_11 tap_12 500.0
R_int_11 tap_11 tap_11_int 2.4
C_sub_11 tap_11 agnd 15.0f
R12 tap_12 tap_13 500.0
R_int_12 tap_12 tap_12_int 2.4
C_sub_12 tap_12 agnd 15.0f
R13 tap_13 tap_14 500.0
R_int_13 tap_13 tap_13_int 2.4
C_sub_13 tap_13 agnd 15.0f
R14 tap_14 tap_15 500.0
R_int_14 tap_14 tap_14_int 2.4
C_sub_14 tap_14 agnd 15.0f
R15 tap_15 tap_16 500.0
R_int_15 tap_15 tap_15_int 2.4
C_sub_15 tap_15 agnd 15.0f
R16 tap_16 tap_17 500.0
R_int_16 tap_16 tap_16_int 2.4
C_sub_16 tap_16 agnd 15.0f
R17 tap_17 tap_18 500.0
R_int_17 tap_17 tap_17_int 2.4
C_sub_17 tap_17 agnd 15.0f
R18 tap_18 tap_19 500.0
R_int_18 tap_18 tap_18_int 2.4
C_sub_18 tap_18 agnd 15.0f
R19 tap_19 tap_20 500.0
R_int_19 tap_19 tap_19_int 2.4
C_sub_19 tap_19 agnd 15.0f
R20 tap_20 tap_21 500.0
R_int_20 tap_20 tap_20_int 2.4
C_sub_20 tap_20 agnd 15.0f
R21 tap_21 tap_22 500.0
R_int_21 tap_21 tap_21_int 2.4
C_sub_21 tap_21 agnd 15.0f
R22 tap_22 tap_23 500.0
R_int_22 tap_22 tap_22_int 2.4
C_sub_22 tap_22 agnd 15.0f
R23 tap_23 tap_24 500.0
R_int_23 tap_23 tap_23_int 2.4
C_sub_23 tap_23 agnd 15.0f
R24 tap_24 tap_25 500.0
R_int_24 tap_24 tap_24_int 2.4
C_sub_24 tap_24 agnd 15.0f
R25 tap_25 tap_26 500.0
R_int_25 tap_25 tap_25_int 2.4
C_sub_25 tap_25 agnd 15.0f
R26 tap_26 tap_27 500.0
R_int_26 tap_26 tap_26_int 2.4
C_sub_26 tap_26 agnd 15.0f
R27 tap_27 tap_28 500.0
R_int_27 tap_27 tap_27_int 2.4
C_sub_27 tap_27 agnd 15.0f
R28 tap_28 tap_29 500.0
R_int_28 tap_28 tap_28_int 2.4
C_sub_28 tap_28 agnd 15.0f
R29 tap_29 tap_30 500.0
R_int_29 tap_29 tap_29_int 2.4
C_sub_29 tap_29 agnd 15.0f
R30 tap_30 tap_31 500.0
R_int_30 tap_30 tap_30_int 2.4
C_sub_30 tap_30 agnd 15.0f
R31 tap_31 tap_32 500.0
R_int_31 tap_31 tap_31_int 2.4
C_sub_31 tap_31 agnd 15.0f
R_top vref tap_32 1.8
R_bot tap_0 vss 2500.0
B_mux vout vss V = 0.72 + (v(vref) - 0.72) * ((v(d4)*16 + v(d3)*8 + v(d2)*4 + v(d1)*2 + v(d0)) / 31.0)
C_out vout agnd 45.0f
.ends dac_5bit_pex
