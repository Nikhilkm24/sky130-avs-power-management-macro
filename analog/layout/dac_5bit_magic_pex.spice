* SPICE3 file created from dac_5bit_array.ext - technology: sky130A

.option scale=10000u

C0 TAP_29_P TAP_31_P 0.00fF
C1 TAP_12_N TAP_13_N 0.01fF
C2 TAP_10_N TAP_11_N 0.01fF
C3 TAP_6_P AGND 0.01fF
C4 TAP_18_N TAP_2_N 0.01fF
C5 TAP_15_P TAP_13_P 0.00fF
C6 TAP_2_P TAP_14_P 0.03fF
C7 TAP_11_N TAP_16_P 0.01fF
C8 TAP_7_N TAP_8_N 0.03fF
C9 TAP_24_N TAP_19_N 0.01fF
C10 TAP_20_N TAP_15_P 0.01fF
C11 TAP_3_P AGND 0.01fF
C12 TAP_1_N TAP_13_N 0.01fF
C13 TAP_23_N TAP_25_N 0.01fF
C14 TAP_25_P TAP_23_P 0.01fF
C15 TAP_8_N TAP_19_P 0.01fF
C16 TAP_13_P TAP_13_N 0.01fF
C17 TAP_0_P TAP_1_P 0.01fF
C18 TAP_26_P TAP_10_P 0.01fF
C19 TAP_0_N TAP_15_N 0.03fF
C20 TAP_8_N TAP_6_N 0.03fF
C21 TAP_30_N TAP_28_N 0.00fF
C22 TAP_15_N AGND 0.01fF
C23 TAP_12_N TAP_2_N 0.01fF
C24 TAP_24_P TAP_23_P 0.03fF
C25 TAP_4_P TAP_9_P 0.01fF
C26 TAP_3_N AGND 0.01fF
C27 TAP_11_P TAP_9_P 0.00fF
C28 AGND TAP_28_N 0.01fF
C29 TAP_7_P TAP_23_P 0.01fF
C30 TAP_31_P TAP_4_N 0.01fF
C31 TAP_12_P AGND 0.01fF
C32 TAP_2_P TAP_3_P 0.01fF
C33 TAP_30_N TAP_14_N 0.01fF
C34 TAP_0_N TAP_14_N 0.01fF
C35 TAP_23_N TAP_22_N 0.01fF
C36 TAP_31_N TAP_15_P 0.15fF
C37 TAP_14_N AGND 0.01fF
C38 TAP_18_N TAP_29_N 0.03fF
C39 TAP_1_N TAP_2_N 0.01fF
C40 TAP_0_P TAP_16_P 0.01fF
C41 TAP_8_N TAP_24_P 0.15fF
C42 TAP_17_P TAP_19_P 0.00fF
C43 TAP_4_N TAP_9_N 0.01fF
C44 TAP_20_P TAP_25_P 0.01fF
C45 TAP_2_P TAP_12_P 0.01fF
C46 TAP_21_P TAP_23_P 0.00fF
C47 TAP_24_N TAP_23_N 0.03fF
C48 TAP_29_N TAP_17_N 0.01fF
C49 TAP_7_N AGND 0.01fF
C50 TAP_4_P TAP_5_P 0.01fF
C51 TAP_11_P TAP_5_P 0.01fF
C52 TAP_8_N TAP_5_N 0.01fF
C53 AGND TAP_19_P 0.01fF
C54 AGND TAP_6_N 0.00fF
C55 TAP_29_P TAP_19_P 0.03fF
C56 TAP_8_N TAP_10_N 0.00fF
C57 TAP_8_P TAP_24_P 0.01fF
C58 TAP_29_P TAP_6_N 0.01fF
C59 TAP_23_N TAP_28_P 0.15fF
C60 TAP_6_P TAP_10_P 0.01fF
C61 TAP_26_N TAP_1_P 0.01fF
C62 TAP_8_P TAP_7_P 0.03fF
C63 TAP_26_N TAP_17_N 0.01fF
C64 TAP_18_N TAP_16_N 0.00fF
C65 TAP_13_P TAP_29_N 0.15fF
C66 TAP_18_N TAP_30_N 0.03fF
C67 TAP_17_P TAP_1_P 0.01fF
C68 TAP_20_P TAP_21_P 0.01fF
C69 TAP_27_P TAP_25_P 0.00fF
C70 TAP_17_P TAP_17_N 0.01fF
C71 TAP_24_P AGND 0.01fF
C72 TAP_16_N TAP_17_N 0.01fF
C73 TAP_3_P TAP_14_P 0.01fF
C74 TAP_30_N TAP_17_N 0.03fF
C75 TAP_26_N TAP_10_N 0.01fF
C76 TAP_7_P AGND 0.01fF
C77 AGND TAP_1_P 0.00fF
C78 AGND TAP_17_N 0.00fF
C79 TAP_10_N TAP_17_P 0.01fF
C80 TAP_22_P TAP_23_P 0.01fF
C81 TAP_20_N TAP_20_P 0.01fF
C82 TAP_21_N TAP_5_N 0.01fF
C83 TAP_2_P TAP_18_N 0.15fF
C84 TAP_12_N AGND 0.01fF
C85 TAP_17_P TAP_16_P 0.01fF
C86 TAP_30_P TAP_17_P 0.03fF
C87 TAP_29_N TAP_22_N 0.01fF
C88 TAP_14_P TAP_12_P 0.00fF
C89 TAP_8_P TAP_9_P 0.01fF
C90 TAP_4_N TAP_6_N 0.00fF
C91 TAP_20_N TAP_26_N 0.03fF
C92 TAP_31_N TAP_29_N 0.00fF
C93 TAP_16_N TAP_16_P 0.01fF
C94 TAP_10_N AGND 0.00fF
C95 TAP_25_N TAP_26_N 0.01fF
C96 TAP_21_N TAP_21_P 0.01fF
C97 TAP_30_P TAP_30_N 0.01fF
C98 TAP_2_P TAP_1_P 0.01fF
C99 TAP_17_P TAP_18_P 0.01fF
C100 TAP_27_P TAP_21_P 0.01fF
C101 TAP_26_P TAP_25_P 0.01fF
C102 TAP_0_N TAP_1_N 0.01fF
C103 TAP_27_N TAP_16_P 0.15fF
C104 TAP_14_P TAP_14_N 0.01fF
C105 AGND TAP_16_P 0.01fF
C106 TAP_11_P TAP_11_N 0.01fF
C107 TAP_30_P TAP_21_N 0.15fF
C108 AGND TAP_1_N 0.01fF
C109 TAP_27_P TAP_16_P 0.01fF
C110 TAP_24_N TAP_8_N 0.01fF
C111 TAP_13_P AGND 0.00fF
C112 TAP_9_P AGND 0.01fF
C113 TAP_26_P TAP_24_P 0.00fF
C114 TAP_29_P TAP_30_P 0.01fF
C115 TAP_19_N TAP_29_N 0.03fF
C116 TAP_20_N TAP_27_N 0.03fF
C117 TAP_28_P TAP_23_P 0.01fF
C118 TAP_3_P TAP_3_N 0.01fF
C119 TAP_20_P TAP_22_P 0.00fF
C120 TAP_20_N AGND 0.01fF
C121 TAP_20_N TAP_21_N 0.01fF
C122 TAP_29_P TAP_13_P 0.01fF
C123 TAP_25_N TAP_27_N 0.00fF
C124 TAP_11_P TAP_4_P 0.03fF
C125 TAP_3_P TAP_12_P 0.03fF
C126 TAP_25_N TAP_21_N 0.03fF
C127 TAP_26_N TAP_22_N 0.01fF
C128 TAP_8_P TAP_5_P 0.01fF
C129 TAP_29_P TAP_18_P 0.03fF
C130 TAP_15_P TAP_0_P 0.03fF
C131 TAP_2_N TAP_13_N 0.03fF
C132 TAP_2_P TAP_13_P 0.03fF
C133 TAP_4_N TAP_5_N 0.01fF
C134 TAP_7_N TAP_9_N 0.01fF
C135 TAP_24_N TAP_26_N 0.00fF
C136 TAP_2_P TAP_18_P 0.01fF
C137 TAP_31_N TAP_16_N 0.03fF
C138 TAP_12_P TAP_28_N 0.15fF
C139 TAP_26_P TAP_10_N 0.15fF
C140 TAP_31_N TAP_30_N 0.01fF
C141 TAP_26_P TAP_21_P 0.03fF
C142 TAP_23_N TAP_23_P 0.01fF
C143 TAP_2_P TAP_25_N 0.01fF
C144 TAP_5_P AGND 0.01fF
C145 TAP_22_N AGND 0.00fF
C146 TAP_21_N TAP_22_N 0.01fF
C147 TAP_15_N TAP_14_N 0.01fF
C148 TAP_10_N TAP_4_N 0.03fF
C149 TAP_31_N AGND 0.01fF
C150 TAP_3_N TAP_14_N 0.01fF
C151 TAP_6_P TAP_6_N 0.01fF
C152 TAP_9_N TAP_6_N 0.03fF
C153 AGND TAP_22_P 0.00fF
C154 TAP_29_P TAP_22_N 0.15fF
C155 TAP_3_P TAP_19_P 0.01fF
C156 TAP_19_N TAP_30_N 0.01fF
C157 TAP_24_N AGND 0.01fF
C158 TAP_29_P TAP_22_P 0.01fF
C159 TAP_24_N TAP_21_N 0.01fF
C160 TAP_14_P TAP_1_P 0.03fF
C161 TAP_19_N AGND 0.01fF
C162 TAP_20_N TAP_4_N 0.01fF
C163 TAP_25_P TAP_9_N 0.15fF
C164 TAP_29_N TAP_13_N 0.01fF
C165 TAP_10_N TAP_10_P 0.01fF
C166 TAP_6_P TAP_7_P 0.01fF
C167 TAP_28_P AGND 0.01fF
C168 TAP_9_N TAP_5_N 0.03fF
C169 TAP_3_P TAP_1_P 0.00fF
C170 TAP_31_P TAP_16_P 0.03fF
C171 TAP_31_P TAP_30_P 0.01fF
C172 TAP_10_P TAP_9_P 0.01fF
C173 TAP_30_P TAP_14_P 0.01fF
C174 TAP_29_P TAP_28_P 0.01fF
C175 TAP_26_P TAP_22_P 0.01fF
C176 TAP_4_P TAP_20_P 0.01fF
C177 TAP_13_P TAP_14_P 0.01fF
C178 TAP_18_N TAP_28_N 0.01fF
C179 TAP_31_P TAP_18_P 0.01fF
C180 TAP_10_N TAP_9_N 0.01fF
C181 TAP_7_N TAP_6_N 0.01fF
C182 TAP_31_P TAP_20_N 0.15fF
C183 TAP_15_P AGND 0.01fF
C184 TAP_23_N AGND 0.01fF
C185 TAP_23_N TAP_21_N 0.00fF
C186 TAP_11_N TAP_27_N 0.01fF
C187 TAP_11_N AGND 0.01fF
C188 TAP_6_P TAP_9_P 0.03fF
C189 TAP_9_P TAP_9_N 0.01fF
C190 TAP_27_P TAP_11_N 0.15fF
C191 TAP_9_N TAP_18_P 0.01fF
C192 TAP_12_N TAP_3_N 0.03fF
C193 AGND TAP_13_N 0.01fF
C194 TAP_10_P TAP_5_P 0.03fF
C195 TAP_12_N TAP_28_N 0.01fF
C196 TAP_25_N TAP_9_N 0.01fF
C197 TAP_3_P TAP_13_P 0.03fF
C198 TAP_12_N TAP_12_P 0.01fF
C199 TAP_2_P TAP_15_P 0.01fF
C200 TAP_4_P AGND 0.01fF
C201 TAP_11_P AGND 0.01fF
C202 TAP_7_N TAP_7_P 0.01fF
C203 TAP_31_N TAP_31_P 0.01fF
C204 TAP_11_P TAP_27_P 0.01fF
C205 TAP_12_N TAP_14_N 0.00fF
C206 TAP_15_N TAP_1_N 0.03fF
C207 TAP_24_P TAP_19_P 0.01fF
C208 TAP_3_N TAP_1_N 0.00fF
C209 TAP_7_N TAP_5_N 0.00fF
C210 TAP_6_P TAP_5_P 0.01fF
C211 TAP_13_P TAP_12_P 0.01fF
C212 TAP_0_N TAP_2_N 0.00fF
C213 TAP_16_N TAP_0_P 0.15fF
C214 AGND TAP_2_N 0.01fF
C215 TAP_0_N TAP_0_P 0.01fF
C216 TAP_14_N TAP_1_N 0.03fF
C217 TAP_6_P TAP_22_P 0.01fF
C218 TAP_0_P TAP_27_N 0.01fF
C219 TAP_0_P AGND 0.01fF
C220 TAP_6_N TAP_5_N 0.01fF
C221 TAP_24_P TAP_25_P 0.01fF
C222 TAP_4_N TAP_11_N 0.03fF
C223 TAP_10_N TAP_6_N 0.01fF
C224 AGND TAP_23_P 0.01fF
C225 TAP_2_P TAP_2_N 0.01fF
C226 TAP_8_N TAP_8_P 0.01fF
C227 TAP_24_N TAP_3_P 0.01fF
C228 TAP_30_P TAP_19_P 0.01fF
C229 TAP_31_N TAP_15_N 0.01fF
C230 TAP_18_N TAP_17_N 0.01fF
C231 TAP_2_P TAP_0_P 0.00fF
C232 TAP_3_P TAP_19_N 0.15fF
C233 TAP_4_P TAP_4_N 0.01fF
C234 TAP_30_N TAP_29_N 0.01fF
C235 TAP_19_P TAP_18_P 0.01fF
C236 TAP_1_P TAP_17_N 0.15fF
C237 TAP_21_P TAP_25_P 0.03fF
C238 TAP_29_N AGND 0.00fF
C239 TAP_8_N AGND 0.01fF
C240 TAP_31_P TAP_15_P 0.01fF
C241 TAP_15_P TAP_14_P 0.01fF
C242 TAP_19_N TAP_3_N 0.01fF
C243 TAP_24_P TAP_21_P 0.01fF
C244 TAP_29_P TAP_29_N 0.01fF
C245 TAP_19_N TAP_28_N 0.03fF
C246 TAP_9_P TAP_25_P 0.01fF
C247 TAP_26_N TAP_17_P 0.15fF
C248 TAP_25_P TAP_18_P 0.01fF
C249 TAP_20_P AGND 0.01fF
C250 TAP_25_N TAP_25_P 0.01fF
C251 TAP_27_P TAP_20_P 0.03fF
C252 TAP_4_P TAP_10_P 0.03fF
C253 TAP_11_P TAP_10_P 0.01fF
C254 TAP_10_N TAP_5_N 0.03fF
C255 TAP_21_P TAP_5_N 0.15fF
C256 TAP_18_N TAP_18_P 0.01fF
C257 TAP_1_N TAP_1_P 0.01fF
C258 TAP_7_P TAP_9_P 0.01fF
C259 TAP_13_P TAP_1_P 0.01fF
C260 TAP_26_N TAP_27_N 0.01fF
C261 TAP_18_N TAP_25_N 0.01fF
C262 TAP_1_N TAP_17_N 0.01fF
C263 TAP_28_P TAP_28_N 0.01fF
C264 TAP_22_N TAP_6_N 0.01fF
C265 TAP_26_N AGND 0.00fF
C266 TAP_26_N TAP_21_N 0.03fF
C267 TAP_30_P TAP_5_N 0.01fF
C268 TAP_28_P TAP_12_P 0.01fF
C269 TAP_11_N TAP_9_N 0.00fF
C270 TAP_8_P AGND 0.01fF
C271 TAP_16_N TAP_30_N 0.01fF
C272 TAP_22_P TAP_6_N 0.15fF
C273 TAP_17_P AGND 0.00fF
C274 TAP_0_N TAP_16_N 0.01fF
C275 TAP_24_N TAP_19_P 0.15fF
C276 TAP_16_N TAP_27_N 0.01fF
C277 TAP_30_P TAP_21_P 0.01fF
C278 TAP_16_N AGND 0.01fF
C279 TAP_19_N TAP_19_P 0.01fF
C280 TAP_4_P TAP_6_P 0.00fF
C281 TAP_29_P TAP_17_P 0.01fF
C282 TAP_21_N TAP_30_N 0.01fF
C283 TAP_0_N AGND 0.01fF
C284 TAP_15_N TAP_15_P 0.01fF
C285 AGND TAP_27_N 0.01fF
C286 TAP_30_P TAP_16_P 0.01fF
C287 TAP_21_N TAP_27_N 0.01fF
C288 TAP_25_P TAP_22_P 0.03fF
C289 TAP_23_N TAP_28_N 0.01fF
C290 TAP_7_N TAP_28_P 0.01fF
C291 TAP_27_P TAP_27_N 0.01fF
C292 TAP_18_N TAP_31_N 0.01fF
C293 TAP_14_P TAP_0_P 0.01fF
C294 TAP_27_P AGND 0.01fF
C295 TAP_23_N TAP_12_P 0.01fF
C296 TAP_7_P TAP_5_P 0.00fF
C297 TAP_26_P TAP_20_P 0.03fF
C298 TAP_29_P AGND 0.00fF
C299 TAP_16_P TAP_18_P 0.00fF
C300 TAP_30_P TAP_18_P 0.03fF
C301 TAP_15_N TAP_13_N 0.00fF
C302 TAP_24_P TAP_22_P 0.03fF
C303 TAP_3_N TAP_13_N 0.03fF
C304 TAP_28_P TAP_19_P 0.03fF
C305 TAP_20_P TAP_4_N 0.15fF
C306 TAP_31_N TAP_17_N 0.03fF
C307 TAP_5_P TAP_5_N 0.01fF
C308 TAP_24_N TAP_24_P 0.01fF
C309 TAP_26_N TAP_26_P 0.01fF
C310 TAP_18_N TAP_19_N 0.01fF
C311 TAP_25_N TAP_18_P 0.15fF
C312 TAP_20_N TAP_25_N 0.01fF
C313 TAP_14_N TAP_13_N 0.01fF
C314 TAP_7_N TAP_23_N 0.01fF
C315 TAP_26_P TAP_17_P 0.01fF
C316 TAP_21_P TAP_5_P 0.01fF
C317 TAP_19_N TAP_17_N 0.00fF
C318 TAP_21_P TAP_22_P 0.01fF
C319 TAP_15_N TAP_2_N 0.01fF
C320 TAP_3_N TAP_2_N 0.01fF
C321 TAP_26_P AGND 0.00fF
C322 TAP_5_P TAP_9_P 0.03fF
C323 TAP_13_P TAP_22_N 0.01fF
C324 TAP_27_P TAP_26_P 0.01fF
C325 TAP_4_N AGND 0.01fF
C326 TAP_20_N TAP_22_N 0.00fF
C327 TAP_31_P TAP_20_P 0.01fF
C328 TAP_25_N TAP_22_N 0.03fF
C329 TAP_31_N TAP_20_N 0.01fF
C330 TAP_14_N TAP_2_N 0.03fF
C331 TAP_8_N TAP_9_N 0.01fF
C332 TAP_8_P TAP_10_P 0.00fF
C333 TAP_24_N TAP_25_N 0.01fF
C334 TAP_31_P TAP_17_P 0.03fF
C335 TAP_15_P TAP_1_P 0.03fF
C336 TAP_28_P TAP_30_P 0.00fF
C337 TAP_14_P TAP_30_N 0.15fF
C338 TAP_10_P AGND 0.01fF
C339 TAP_29_N TAP_28_N 0.01fF
C340 TAP_22_N TAP_22_P 0.01fF
C341 TAP_8_P TAP_6_P 0.03fF
C342 TAP_31_P AGND 0.01fF
C343 TAP_14_P TAP_21_N 0.01fF
C344 TAP_11_N TAP_5_N 0.01fF
C345 TAP_28_P TAP_18_P 0.01fF
C346 TAP_7_N TAP_23_P 0.15fF
C347 TAP_24_N TAP_22_N 0.03fF
C348 V_BOT $SUB 1.85fF **FLOATING
C349 V_REF $SUB 1.85fF **FLOATING
C350 TAP_12_N $SUB 0.15fF **FLOATING
C351 TAP_3_N $SUB 0.15fF **FLOATING
C352 TAP_13_N $SUB 0.15fF **FLOATING
C353 TAP_2_N $SUB 0.15fF **FLOATING
C354 TAP_14_N $SUB 0.15fF **FLOATING
C355 TAP_1_N $SUB 0.15fF **FLOATING
C356 TAP_15_N $SUB 0.15fF **FLOATING
C357 TAP_0_N $SUB 0.15fF **FLOATING
C358 TAP_12_P $SUB 0.15fF **FLOATING
C359 TAP_3_P $SUB 0.15fF **FLOATING
C360 TAP_13_P $SUB 0.04fF **FLOATING
C361 TAP_2_P $SUB 0.04fF **FLOATING
C362 TAP_14_P $SUB 0.06fF **FLOATING
C363 TAP_1_P $SUB 0.15fF **FLOATING
C364 TAP_15_P $SUB 0.04fF **FLOATING
C365 TAP_0_P $SUB 0.06fF **FLOATING
C366 TAP_28_N $SUB 0.15fF **FLOATING
C367 TAP_19_N $SUB 0.15fF **FLOATING
C368 TAP_29_N $SUB 0.04fF **FLOATING
C369 TAP_18_N $SUB 0.04fF **FLOATING
C370 TAP_30_N $SUB 0.06fF **FLOATING
C371 TAP_17_N $SUB 0.15fF **FLOATING
C372 TAP_31_N $SUB 0.04fF **FLOATING
C373 TAP_16_N $SUB 0.06fF **FLOATING
C374 TAP_28_P $SUB 0.15fF **FLOATING
C375 TAP_19_P $SUB 0.15fF **FLOATING
C376 TAP_29_P $SUB 0.04fF **FLOATING
C377 TAP_18_P $SUB 0.04fF **FLOATING
C378 TAP_30_P $SUB 0.06fF **FLOATING
C379 TAP_17_P $SUB 0.15fF **FLOATING
C380 TAP_31_P $SUB 0.04fF **FLOATING
C381 TAP_16_P $SUB 0.06fF **FLOATING
C382 TAP_23_N $SUB 0.15fF **FLOATING
C383 TAP_24_N $SUB 0.15fF **FLOATING
C384 TAP_22_N $SUB 0.04fF **FLOATING
C385 TAP_25_N $SUB 0.04fF **FLOATING
C386 TAP_21_N $SUB 0.06fF **FLOATING
C387 TAP_26_N $SUB 0.15fF **FLOATING
C388 TAP_20_N $SUB 0.04fF **FLOATING
C389 TAP_27_N $SUB 0.06fF **FLOATING
C390 TAP_23_P $SUB 0.15fF **FLOATING
C391 TAP_24_P $SUB 0.15fF **FLOATING
C392 TAP_22_P $SUB 0.04fF **FLOATING
C393 TAP_25_P $SUB 0.04fF **FLOATING
C394 TAP_21_P $SUB 0.06fF **FLOATING
C395 TAP_26_P $SUB 0.15fF **FLOATING
C396 TAP_20_P $SUB 0.04fF **FLOATING
C397 TAP_27_P $SUB 0.06fF **FLOATING
C398 TAP_7_N $SUB 0.15fF **FLOATING
C399 TAP_8_N $SUB 0.15fF **FLOATING
C400 TAP_6_N $SUB 0.04fF **FLOATING
C401 TAP_9_N $SUB 0.04fF **FLOATING
C402 TAP_5_N $SUB 0.06fF **FLOATING
C403 TAP_10_N $SUB 0.15fF **FLOATING
C404 TAP_4_N $SUB 0.04fF **FLOATING
C405 TAP_11_N $SUB 0.06fF **FLOATING
C406 TAP_7_P $SUB 0.15fF **FLOATING
C407 TAP_8_P $SUB 0.15fF **FLOATING
C408 TAP_6_P $SUB 0.15fF **FLOATING
C409 TAP_9_P $SUB 0.15fF **FLOATING
C410 TAP_5_P $SUB 0.15fF **FLOATING
C411 TAP_10_P $SUB 0.15fF **FLOATING
C412 TAP_4_P $SUB 0.15fF **FLOATING
C413 TAP_11_P $SUB 0.15fF **FLOATING
C414 AGND $SUB 14.25fF **FLOATING
