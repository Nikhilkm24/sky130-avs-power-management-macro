* NGSPICE file created from dac_5bit_array.ext - technology: sky130A

.global w<0.42 a1<0.47 a1<11.57 a1<2.01 a1<1.01

* Top level circuit dac_5bit_array

C0 TAP_1_P TAP_0_P 0.01fF
C1 TAP_15_N TAP_31_N 0.01fF
C2 TAP_2_P TAP_12_P 0.01fF
C3 TAP_22_P TAP_6_N 0.15fF
C4 TAP_15_P TAP_2_P 0.01fF
C5 TAP_17_P TAP_19_P 0.00fF
C6 TAP_5_P TAP_10_P 0.03fF
C7 TAP_26_P TAP_24_P 0.00fF
C8 TAP_27_N TAP_27_P 0.01fF
C9 TAP_17_N TAP_30_N 0.03fF
C10 TAP_0_N TAP_15_N 0.03fF
C11 TAP_19_N TAP_28_N 0.03fF
C12 AGND TAP_20_N 0.01fF
C13 AGND TAP_9_P 0.01fF
C14 TAP_30_N TAP_30_P 0.01fF
C15 TAP_16_N TAP_30_N 0.01fF
C16 AGND TAP_23_N 0.01fF
C17 TAP_29_P TAP_19_P 0.03fF
C18 TAP_13_N TAP_15_N 0.00fF
C19 TAP_15_P TAP_1_P 0.03fF
C20 TAP_26_P TAP_27_P 0.01fF
C21 TAP_20_P TAP_20_N 0.01fF
C22 TAP_18_N TAP_31_N 0.01fF
C23 TAP_27_N TAP_26_N 0.01fF
C24 TAP_25_N TAP_24_N 0.01fF
C25 TAP_17_N TAP_26_N 0.01fF
C26 AGND TAP_19_P 0.01fF
C27 TAP_7_N TAP_5_N 0.00fF
C28 TAP_28_P TAP_23_N 0.15fF
C29 TAP_13_P TAP_14_P 0.01fF
C30 TAP_24_P TAP_8_P 0.01fF
C31 TAP_5_P TAP_9_P 0.03fF
C32 TAP_23_P TAP_7_P 0.01fF
C33 TAP_3_N TAP_1_N 0.00fF
C34 TAP_15_P TAP_20_N 0.01fF
C35 TAP_18_N TAP_18_P 0.01fF
C36 TAP_13_P TAP_13_N 0.01fF
C37 TAP_30_N TAP_28_N 0.00fF
C38 TAP_2_P TAP_25_N 0.01fF
C39 TAP_12_P TAP_23_N 0.01fF
C40 TAP_4_P TAP_6_P 0.00fF
C41 TAP_8_N TAP_8_P 0.01fF
C42 TAP_4_P TAP_4_N 0.01fF
C43 TAP_17_N TAP_1_P 0.15fF
C44 TAP_13_P TAP_22_N 0.01fF
C45 TAP_2_N TAP_15_N 0.01fF
C46 TAP_11_P TAP_27_P 0.01fF
C47 TAP_26_N TAP_25_N 0.01fF
C48 TAP_13_P TAP_3_P 0.03fF
C49 TAP_7_N TAP_8_N 0.03fF
C50 TAP_19_P TAP_28_P 0.03fF
C51 TAP_17_P TAP_29_P 0.01fF
C52 TAP_26_P TAP_10_N 0.15fF
C53 TAP_26_N TAP_26_P 0.01fF
C54 TAP_7_N TAP_23_P 0.15fF
C55 TAP_3_N AGND 0.01fF
C56 TAP_25_P TAP_25_N 0.01fF
C57 TAP_10_P TAP_26_P 0.01fF
C58 TAP_26_P TAP_25_P 0.01fF
C59 TAP_11_N TAP_4_N 0.03fF
C60 TAP_27_N TAP_20_N 0.03fF
C61 TAP_17_P AGND 0.00fF
C62 TAP_31_P TAP_4_N 0.01fF
C63 TAP_11_P TAP_10_P 0.01fF
C64 TAP_14_P TAP_3_P 0.01fF
C65 TAP_18_N TAP_2_N 0.01fF
C66 TAP_17_P TAP_16_P 0.01fF
C67 TAP_29_P AGND 0.00fF
C68 TAP_5_N TAP_4_N 0.01fF
C69 TAP_1_N AGND 0.01fF
C70 TAP_25_N TAP_20_N 0.01fF
C71 TAP_22_P TAP_29_P 0.01fF
C72 TAP_10_P TAP_8_P 0.00fF
C73 TAP_25_N TAP_23_N 0.01fF
C74 TAP_19_N TAP_18_N 0.01fF
C75 TAP_31_P TAP_31_N 0.01fF
C76 TAP_0_N TAP_2_N 0.00fF
C77 TAP_30_P TAP_19_P 0.01fF
C78 TAP_29_P TAP_28_P 0.01fF
C79 TAP_22_P AGND 0.00fF
C80 TAP_12_N TAP_13_N 0.01fF
C81 TAP_31_P TAP_18_P 0.01fF
C82 AGND TAP_0_P 0.01fF
C83 TAP_28_N TAP_23_N 0.01fF
C84 TAP_9_P TAP_7_P 0.01fF
C85 TAP_7_N TAP_6_N 0.01fF
C86 TAP_2_N TAP_13_N 0.03fF
C87 TAP_21_N TAP_14_P 0.01fF
C88 TAP_16_P AGND 0.01fF
C89 TAP_11_P TAP_9_P 0.00fF
C90 TAP_20_P AGND 0.01fF
C91 TAP_14_N TAP_15_N 0.01fF
C92 AGND TAP_28_P 0.01fF
C93 TAP_21_P TAP_21_N 0.01fF
C94 TAP_22_P TAP_20_P 0.00fF
C95 TAP_16_P TAP_0_P 0.01fF
C96 TAP_29_N TAP_29_P 0.01fF
C97 TAP_9_P TAP_8_P 0.01fF
C98 TAP_5_P AGND 0.01fF
C99 TAP_21_N TAP_22_N 0.01fF
C100 TAP_17_P TAP_17_N 0.01fF
C101 TAP_18_N TAP_30_N 0.03fF
C102 TAP_21_P TAP_5_N 0.15fF
C103 TAP_7_N TAP_23_N 0.01fF
C104 TAP_12_P AGND 0.01fF
C105 TAP_15_P AGND 0.01fF
C106 TAP_19_N TAP_3_P 0.15fF
C107 TAP_9_N TAP_25_N 0.01fF
C108 TAP_12_N TAP_2_N 0.01fF
C109 TAP_17_P TAP_30_P 0.03fF
C110 TAP_21_P TAP_24_P 0.01fF
C111 TAP_29_N AGND 0.00fF
C112 TAP_30_N TAP_31_N 0.01fF
C113 TAP_4_N TAP_10_N 0.03fF
C114 TAP_15_P TAP_0_P 0.03fF
C115 TAP_2_P TAP_13_P 0.03fF
C116 TAP_17_N TAP_1_N 0.01fF
C117 TAP_10_P TAP_6_P 0.01fF
C118 TAP_30_P TAP_29_P 0.01fF
C119 TAP_17_P TAP_26_P 0.01fF
C120 TAP_12_P TAP_28_P 0.01fF
C121 TAP_2_P TAP_18_N 0.15fF
C122 TAP_14_P TAP_30_N 0.15fF
C123 TAP_21_P TAP_23_P 0.00fF
C124 TAP_5_N TAP_11_N 0.01fF
C125 TAP_27_N AGND 0.01fF
C126 TAP_17_N AGND 0.00fF
C127 TAP_21_P TAP_27_P 0.01fF
C128 TAP_13_P TAP_1_P 0.01fF
C129 TAP_6_P TAP_6_N 0.01fF
C130 TAP_4_N TAP_6_N 0.00fF
C131 TAP_16_N AGND 0.01fF
C132 TAP_14_N TAP_0_N 0.01fF
C133 TAP_27_N TAP_0_P 0.01fF
C134 TAP_14_N TAP_14_P 0.01fF
C135 TAP_27_N TAP_16_P 0.15fF
C136 TAP_21_N TAP_5_N 0.01fF
C137 TAP_2_P TAP_14_P 0.03fF
C138 TAP_7_N TAP_9_N 0.01fF
C139 TAP_22_N TAP_24_N 0.03fF
C140 TAP_16_N TAP_0_P 0.15fF
C141 TAP_2_P TAP_18_P 0.01fF
C142 TAP_3_P TAP_24_N 0.01fF
C143 TAP_16_P TAP_30_P 0.01fF
C144 TAP_16_N TAP_16_P 0.01fF
C145 TAP_26_P AGND 0.00fF
C146 TAP_20_N TAP_4_N 0.01fF
C147 TAP_6_P TAP_9_P 0.03fF
C148 TAP_14_N TAP_13_N 0.01fF
C149 TAP_30_P TAP_28_P 0.00fF
C150 TAP_27_P TAP_11_N 0.15fF
C151 TAP_22_P TAP_26_P 0.01fF
C152 TAP_18_P TAP_25_P 0.01fF
C153 TAP_2_P TAP_3_P 0.01fF
C154 TAP_26_N TAP_22_N 0.01fF
C155 TAP_14_P TAP_1_P 0.03fF
C156 TAP_21_P TAP_25_P 0.03fF
C157 AGND TAP_28_N 0.01fF
C158 TAP_8_N TAP_5_N 0.01fF
C159 TAP_26_P TAP_20_P 0.03fF
C160 TAP_17_N TAP_29_N 0.01fF
C161 AGND TAP_7_P 0.01fF
C162 TAP_10_P TAP_4_P 0.03fF
C163 TAP_21_N TAP_30_N 0.01fF
C164 TAP_11_P AGND 0.01fF
C165 TAP_14_N TAP_12_N 0.00fF
C166 TAP_20_N TAP_31_N 0.01fF
C167 TAP_8_N TAP_24_P 0.15fF
C168 TAP_19_N TAP_30_N 0.01fF
C169 TAP_24_P TAP_23_P 0.03fF
C170 TAP_14_N TAP_2_N 0.03fF
C171 TAP_1_P TAP_3_P 0.00fF
C172 TAP_21_N TAP_24_N 0.01fF
C173 TAP_11_N TAP_10_N 0.01fF
C174 TAP_2_P TAP_2_N 0.01fF
C175 AGND TAP_8_P 0.01fF
C176 TAP_19_N TAP_24_N 0.01fF
C177 TAP_22_N TAP_6_N 0.01fF
C178 TAP_7_N AGND 0.01fF
C179 TAP_28_P TAP_28_N 0.01fF
C180 TAP_27_N TAP_16_N 0.01fF
C181 TAP_16_N TAP_17_N 0.01fF
C182 TAP_24_P TAP_24_N 0.01fF
C183 TAP_5_P TAP_7_P 0.00fF
C184 TAP_9_N TAP_4_N 0.01fF
C185 TAP_21_N TAP_26_N 0.03fF
C186 TAP_12_P TAP_28_N 0.15fF
C187 TAP_5_P TAP_11_P 0.01fF
C188 TAP_22_N TAP_20_N 0.00fF
C189 TAP_22_N TAP_23_N 0.01fF
C190 TAP_27_N TAP_25_N 0.00fF
C191 TAP_7_N TAP_28_P 0.01fF
C192 TAP_4_P TAP_9_P 0.01fF
C193 TAP_8_N TAP_24_N 0.01fF
C194 TAP_5_N TAP_10_N 0.03fF
C195 TAP_29_N TAP_28_N 0.01fF
C196 TAP_1_N TAP_15_N 0.03fF
C197 TAP_5_P TAP_8_P 0.01fF
C198 TAP_18_P TAP_19_P 0.01fF
C199 TAP_24_P TAP_25_P 0.01fF
C200 AGND TAP_15_N 0.01fF
C201 TAP_3_P TAP_19_P 0.01fF
C202 TAP_8_N TAP_10_N 0.00fF
C203 TAP_5_N TAP_6_N 0.01fF
C204 TAP_13_P TAP_29_P 0.01fF
C205 TAP_31_P TAP_20_N 0.15fF
C206 TAP_14_N TAP_30_N 0.01fF
C207 TAP_21_N TAP_20_N 0.01fF
C208 TAP_25_P TAP_23_P 0.01fF
C209 TAP_18_P TAP_9_N 0.01fF
C210 TAP_21_N TAP_23_N 0.00fF
C211 AGND TAP_6_P 0.01fF
C212 AGND TAP_4_N 0.01fF
C213 TAP_3_N TAP_13_N 0.03fF
C214 TAP_27_P TAP_25_P 0.00fF
C215 TAP_13_P AGND 0.00fF
C216 TAP_22_P TAP_6_P 0.01fF
C217 TAP_26_N TAP_24_N 0.00fF
C218 TAP_8_N TAP_6_N 0.03fF
C219 TAP_3_N TAP_3_P 0.01fF
C220 TAP_17_P TAP_18_P 0.01fF
C221 TAP_15_P TAP_15_N 0.01fF
C222 TAP_20_P TAP_4_N 0.15fF
C223 TAP_0_N TAP_1_N 0.01fF
C224 TAP_19_N TAP_19_P 0.01fF
C225 TAP_18_P TAP_29_P 0.03fF
C226 TAP_3_N TAP_12_N 0.03fF
C227 TAP_26_N TAP_10_N 0.01fF
C228 AGND TAP_31_N 0.01fF
C229 TAP_5_P TAP_6_P 0.01fF
C230 TAP_11_N TAP_9_N 0.00fF
C231 TAP_10_P TAP_10_N 0.01fF
C232 TAP_3_N TAP_2_N 0.01fF
C233 TAP_23_P TAP_23_N 0.01fF
C234 TAP_0_N AGND 0.01fF
C235 TAP_1_N TAP_13_N 0.01fF
C236 TAP_24_P TAP_19_P 0.01fF
C237 TAP_22_N TAP_29_P 0.15fF
C238 TAP_2_P TAP_1_P 0.01fF
C239 TAP_13_P TAP_12_P 0.01fF
C240 TAP_26_N TAP_1_P 0.01fF
C241 TAP_15_P TAP_13_P 0.00fF
C242 TAP_0_N TAP_0_P 0.01fF
C243 TAP_3_N TAP_19_N 0.01fF
C244 TAP_8_N TAP_19_P 0.01fF
C245 TAP_8_P TAP_7_P 0.03fF
C246 AGND TAP_13_N 0.01fF
C247 TAP_14_P TAP_0_P 0.01fF
C248 TAP_10_N TAP_6_N 0.01fF
C249 TAP_13_P TAP_29_N 0.15fF
C250 TAP_7_N TAP_7_P 0.01fF
C251 TAP_24_N TAP_23_N 0.03fF
C252 TAP_31_P TAP_17_P 0.03fF
C253 TAP_22_N AGND 0.00fF
C254 TAP_21_P TAP_22_P 0.01fF
C255 TAP_3_P AGND 0.01fF
C256 TAP_16_P TAP_18_P 0.00fF
C257 TAP_5_N TAP_9_N 0.03fF
C258 TAP_18_N TAP_29_N 0.03fF
C259 TAP_4_P AGND 0.01fF
C260 TAP_22_P TAP_22_N 0.01fF
C261 TAP_18_P TAP_28_P 0.01fF
C262 TAP_15_P TAP_31_N 0.15fF
C263 TAP_1_N TAP_2_N 0.01fF
C264 TAP_26_N TAP_20_N 0.03fF
C265 TAP_21_P TAP_20_P 0.01fF
C266 TAP_31_P TAP_29_P 0.00fF
C267 TAP_10_P TAP_9_P 0.01fF
C268 TAP_19_P TAP_24_N 0.15fF
C269 TAP_29_N TAP_31_N 0.00fF
C270 TAP_14_P TAP_12_P 0.00fF
C271 TAP_15_P TAP_14_P 0.01fF
C272 AGND TAP_12_N 0.01fF
C273 AGND TAP_11_N 0.01fF
C274 TAP_25_P TAP_9_P 0.01fF
C275 TAP_8_N TAP_9_N 0.01fF
C276 TAP_21_P TAP_5_P 0.01fF
C277 TAP_18_N TAP_17_N 0.01fF
C278 TAP_20_P TAP_4_P 0.01fF
C279 AGND TAP_2_N 0.01fF
C280 TAP_16_N TAP_18_N 0.00fF
C281 TAP_31_P AGND 0.01fF
C282 TAP_5_P TAP_4_P 0.01fF
C283 TAP_12_P TAP_3_P 0.03fF
C284 TAP_16_P TAP_11_N 0.01fF
C285 TAP_17_N TAP_31_N 0.03fF
C286 TAP_29_N TAP_13_N 0.01fF
C287 TAP_19_N AGND 0.01fF
C288 TAP_18_N TAP_25_N 0.01fF
C289 TAP_22_N TAP_29_N 0.01fF
C290 TAP_16_N TAP_31_N 0.03fF
C291 TAP_31_P TAP_16_P 0.03fF
C292 TAP_31_P TAP_20_P 0.01fF
C293 TAP_16_N TAP_0_N 0.01fF
C294 TAP_14_N TAP_3_N 0.01fF
C295 TAP_12_P TAP_12_N 0.01fF
C296 TAP_6_P TAP_7_P 0.01fF
C297 TAP_24_P AGND 0.01fF
C298 TAP_14_P TAP_30_P 0.01fF
C299 TAP_30_P TAP_18_P 0.03fF
C300 TAP_22_P TAP_24_P 0.03fF
C301 TAP_9_N TAP_10_N 0.01fF
C302 TAP_21_P TAP_30_P 0.01fF
C303 TAP_18_N TAP_28_N 0.01fF
C304 TAP_8_N AGND 0.01fF
C305 TAP_15_P TAP_31_P 0.01fF
C306 TAP_6_P TAP_8_P 0.03fF
C307 TAP_18_P TAP_25_N 0.15fF
C308 AGND TAP_23_P 0.01fF
C309 TAP_25_P TAP_9_N 0.15fF
C310 TAP_5_P TAP_5_N 0.01fF
C311 TAP_17_P TAP_26_N 0.15fF
C312 TAP_17_P TAP_10_N 0.01fF
C313 TAP_22_P TAP_23_P 0.01fF
C314 TAP_27_P AGND 0.01fF
C315 TAP_21_P TAP_26_P 0.03fF
C316 TAP_22_N TAP_25_N 0.03fF
C317 TAP_27_N TAP_11_N 0.01fF
C318 TAP_19_N TAP_29_N 0.03fF
C319 TAP_14_N TAP_1_N 0.03fF
C320 TAP_9_N TAP_6_N 0.03fF
C321 AGND TAP_24_N 0.01fF
C322 TAP_23_P TAP_28_P 0.01fF
C323 TAP_17_P TAP_1_P 0.01fF
C324 TAP_16_P TAP_27_P 0.01fF
C325 TAP_20_P TAP_27_P 0.03fF
C326 TAP_27_N TAP_21_N 0.01fF
C327 TAP_14_N AGND 0.01fF
C328 TAP_31_P TAP_30_P 0.01fF
C329 TAP_9_P TAP_9_N 0.01fF
C330 TAP_19_N TAP_17_N 0.00fF
C331 TAP_26_N AGND 0.00fF
C332 AGND TAP_10_N 0.00fF
C333 TAP_21_N TAP_30_P 0.15fF
C334 TAP_1_P TAP_1_N 0.01fF
C335 TAP_10_P AGND 0.01fF
C336 TAP_29_P TAP_6_N 0.01fF
C337 TAP_2_P TAP_0_P 0.00fF
C338 TAP_11_P TAP_4_P 0.03fF
C339 TAP_30_P TAP_5_N 0.01fF
C340 TAP_21_N TAP_25_N 0.03fF
C341 TAP_22_P TAP_25_P 0.03fF
C342 TAP_30_N TAP_29_N 0.01fF
C343 TAP_1_P AGND 0.00fF
C344 TAP_12_N TAP_28_N 0.01fF
C345 TAP_11_P TAP_11_N 0.01fF
C346 AGND TAP_6_N 0.00fF
C347 TAP_20_P TAP_25_P 0.01fF
C348 V_BOT $SUB 1.85fF $ **FLOATING
C349 V_REF $SUB 1.85fF $ **FLOATING
C350 TAP_12_N $SUB 0.15fF $ **FLOATING
C351 TAP_3_N $SUB 0.15fF $ **FLOATING
C352 TAP_13_N $SUB 0.15fF $ **FLOATING
C353 TAP_2_N $SUB 0.15fF $ **FLOATING
C354 TAP_14_N $SUB 0.15fF $ **FLOATING
C355 TAP_1_N $SUB 0.15fF $ **FLOATING
C356 TAP_15_N $SUB 0.15fF $ **FLOATING
C357 TAP_0_N $SUB 0.15fF $ **FLOATING
C358 TAP_12_P $SUB 0.15fF $ **FLOATING
C359 TAP_3_P $SUB 0.15fF $ **FLOATING
C360 TAP_13_P $SUB 0.04fF $ **FLOATING
C361 TAP_2_P $SUB 0.04fF $ **FLOATING
C362 TAP_14_P $SUB 0.06fF $ **FLOATING
C363 TAP_1_P $SUB 0.15fF $ **FLOATING
C364 TAP_15_P $SUB 0.04fF $ **FLOATING
C365 TAP_0_P $SUB 0.06fF $ **FLOATING
C366 TAP_28_N $SUB 0.15fF $ **FLOATING
C367 TAP_19_N $SUB 0.15fF $ **FLOATING
C368 TAP_29_N $SUB 0.04fF $ **FLOATING
C369 TAP_18_N $SUB 0.04fF $ **FLOATING
C370 TAP_30_N $SUB 0.06fF $ **FLOATING
C371 TAP_17_N $SUB 0.15fF $ **FLOATING
C372 TAP_31_N $SUB 0.04fF $ **FLOATING
C373 TAP_16_N $SUB 0.06fF $ **FLOATING
C374 TAP_28_P $SUB 0.15fF $ **FLOATING
C375 TAP_19_P $SUB 0.15fF $ **FLOATING
C376 TAP_29_P $SUB 0.04fF $ **FLOATING
C377 TAP_18_P $SUB 0.04fF $ **FLOATING
C378 TAP_30_P $SUB 0.06fF $ **FLOATING
C379 TAP_17_P $SUB 0.15fF $ **FLOATING
C380 TAP_31_P $SUB 0.04fF $ **FLOATING
C381 TAP_16_P $SUB 0.06fF $ **FLOATING
C382 TAP_23_N $SUB 0.15fF $ **FLOATING
C383 TAP_24_N $SUB 0.15fF $ **FLOATING
C384 TAP_22_N $SUB 0.04fF $ **FLOATING
C385 TAP_25_N $SUB 0.04fF $ **FLOATING
C386 TAP_21_N $SUB 0.06fF $ **FLOATING
C387 TAP_26_N $SUB 0.15fF $ **FLOATING
C388 TAP_20_N $SUB 0.04fF $ **FLOATING
C389 TAP_27_N $SUB 0.06fF $ **FLOATING
C390 TAP_23_P $SUB 0.15fF $ **FLOATING
C391 TAP_24_P $SUB 0.15fF $ **FLOATING
C392 TAP_22_P $SUB 0.04fF $ **FLOATING
C393 TAP_25_P $SUB 0.04fF $ **FLOATING
C394 TAP_21_P $SUB 0.06fF $ **FLOATING
C395 TAP_26_P $SUB 0.15fF $ **FLOATING
C396 TAP_20_P $SUB 0.04fF $ **FLOATING
C397 TAP_27_P $SUB 0.06fF $ **FLOATING
C398 TAP_7_N $SUB 0.15fF $ **FLOATING
C399 TAP_8_N $SUB 0.15fF $ **FLOATING
C400 TAP_6_N $SUB 0.04fF $ **FLOATING
C401 TAP_9_N $SUB 0.04fF $ **FLOATING
C402 TAP_5_N $SUB 0.06fF $ **FLOATING
C403 TAP_10_N $SUB 0.15fF $ **FLOATING
C404 TAP_4_N $SUB 0.04fF $ **FLOATING
C405 TAP_11_N $SUB 0.06fF $ **FLOATING
C406 TAP_7_P $SUB 0.15fF $ **FLOATING
C407 TAP_8_P $SUB 0.15fF $ **FLOATING
C408 TAP_6_P $SUB 0.15fF $ **FLOATING
C409 TAP_9_P $SUB 0.15fF $ **FLOATING
C410 TAP_5_P $SUB 0.15fF $ **FLOATING
C411 TAP_10_P $SUB 0.15fF $ **FLOATING
C412 TAP_4_P $SUB 0.15fF $ **FLOATING
C413 TAP_11_P $SUB 0.15fF $ **FLOATING
C414 AGND $SUB 14.25fF $ **FLOATING
.end
